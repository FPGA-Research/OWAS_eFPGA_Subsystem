* NGSPICE file created from psum_requant_container.ext - technology: ihp-sg13cmos5l

* Black-box entry subcircuit for sg13cmos5l_decap_4 abstract view
.subckt sg13cmos5l_decap_4 VDD VSS
.ends

* Black-box entry subcircuit for sg13cmos5l_fill_1 abstract view
.subckt sg13cmos5l_fill_1 VDD VSS
.ends

* Black-box entry subcircuit for sg13cmos5l_fill_2 abstract view
.subckt sg13cmos5l_fill_2 VDD VSS
.ends

* Black-box entry subcircuit for sg13cmos5l_o21ai_1 abstract view
.subckt sg13cmos5l_o21ai_1 Y A1 A2 B1 VDD VSS
.ends

* Black-box entry subcircuit for sg13cmos5l_nor2_1 abstract view
.subckt sg13cmos5l_nor2_1 Y A B VDD VSS
.ends

* Black-box entry subcircuit for sg13cmos5l_a21o_1 abstract view
.subckt sg13cmos5l_a21o_1 X A1 A2 B1 VDD VSS
.ends

* Black-box entry subcircuit for sg13cmos5l_nor2b_1 abstract view
.subckt sg13cmos5l_nor2b_1 Y A B_N VDD VSS
.ends

* Black-box entry subcircuit for sg13cmos5l_xor2_1 abstract view
.subckt sg13cmos5l_xor2_1 X A B VDD VSS
.ends

* Black-box entry subcircuit for sg13cmos5l_xnor2_1 abstract view
.subckt sg13cmos5l_xnor2_1 Y A B VDD VSS
.ends

* Black-box entry subcircuit for sg13cmos5l_decap_8 abstract view
.subckt sg13cmos5l_decap_8 VDD VSS
.ends

* Black-box entry subcircuit for sg13cmos5l_buf_1 abstract view
.subckt sg13cmos5l_buf_1 X A VDD VSS
.ends

* Black-box entry subcircuit for sg13cmos5l_nand2_1 abstract view
.subckt sg13cmos5l_nand2_1 Y A B VDD VSS
.ends

* Black-box entry subcircuit for sg13cmos5l_buf_2 abstract view
.subckt sg13cmos5l_buf_2 X A VDD VSS
.ends

* Black-box entry subcircuit for sg13cmos5l_nor2b_2 abstract view
.subckt sg13cmos5l_nor2b_2 Y A B_N VDD VSS
.ends

* Black-box entry subcircuit for sg13cmos5l_and2_1 abstract view
.subckt sg13cmos5l_and2_1 X A B VDD VSS
.ends

* Black-box entry subcircuit for sg13cmos5l_a21oi_1 abstract view
.subckt sg13cmos5l_a21oi_1 Y A1 A2 B1 VDD VSS
.ends

* Black-box entry subcircuit for sg13cmos5l_mux2_1 abstract view
.subckt sg13cmos5l_mux2_1 X A0 A1 S VDD VSS
.ends

* Black-box entry subcircuit for sg13cmos5l_dfrbpq_1 abstract view
.subckt sg13cmos5l_dfrbpq_1 Q CLK D RESET_B VDD VSS
.ends

* Black-box entry subcircuit for sg13cmos5l_inv_1 abstract view
.subckt sg13cmos5l_inv_1 Y A VDD VSS
.ends

* Black-box entry subcircuit for sg13cmos5l_a22oi_1 abstract view
.subckt sg13cmos5l_a22oi_1 Y A1 A2 B1 B2 VDD VSS
.ends

* Black-box entry subcircuit for sg13cmos5l_tiehi abstract view
.subckt sg13cmos5l_tiehi L_HI VDD VSS
.ends

* Black-box entry subcircuit for sg13cmos5l_nor3_1 abstract view
.subckt sg13cmos5l_nor3_1 Y A B C VDD VSS
.ends

* Black-box entry subcircuit for sg13cmos5l_nand2_2 abstract view
.subckt sg13cmos5l_nand2_2 Y A B VDD VSS
.ends

* Black-box entry subcircuit for sg13cmos5l_nand2b_1 abstract view
.subckt sg13cmos5l_nand2b_1 Y A_N B VDD VSS
.ends

* Black-box entry subcircuit for sg13cmos5l_nand3_1 abstract view
.subckt sg13cmos5l_nand3_1 Y A B C VDD VSS
.ends

* Black-box entry subcircuit for sg13cmos5l_inv_2 abstract view
.subckt sg13cmos5l_inv_2 Y A VDD VSS
.ends

* Black-box entry subcircuit for sg13cmos5l_antennanp abstract view
.subckt sg13cmos5l_antennanp A VDD VSS
.ends

* Black-box entry subcircuit for sg13cmos5l_nor2_2 abstract view
.subckt sg13cmos5l_nor2_2 Y A B VDD VSS
.ends

* Black-box entry subcircuit for sg13cmos5l_dfrbpq_2 abstract view
.subckt sg13cmos5l_dfrbpq_2 Q CLK D RESET_B VDD VSS
.ends

* Black-box entry subcircuit for sg13cmos5l_buf_8 abstract view
.subckt sg13cmos5l_buf_8 X A VDD VSS
.ends

* Black-box entry subcircuit for sg13cmos5l_tielo abstract view
.subckt sg13cmos5l_tielo L_LO VDD VSS
.ends

* Black-box entry subcircuit for sg13cmos5l_and3_1 abstract view
.subckt sg13cmos5l_and3_1 X A B C VDD VSS
.ends

* Black-box entry subcircuit for sg13cmos5l_nor4_1 abstract view
.subckt sg13cmos5l_nor4_1 Y A B C D VDD VSS
.ends

* Black-box entry subcircuit for sg13cmos5l_nand4_1 abstract view
.subckt sg13cmos5l_nand4_1 Y A B C D VDD VSS
.ends

* Black-box entry subcircuit for sg13cmos5l_buf_16 abstract view
.subckt sg13cmos5l_buf_16 X A VDD VSS
.ends

* Black-box entry subcircuit for sg13cmos5l_and2_2 abstract view
.subckt sg13cmos5l_and2_2 X A B VDD VSS
.ends

* Black-box entry subcircuit for sg13cmos5l_buf_4 abstract view
.subckt sg13cmos5l_buf_4 X A VDD VSS
.ends

* Black-box entry subcircuit for sg13cmos5l_a221oi_1 abstract view
.subckt sg13cmos5l_a221oi_1 Y A1 A2 B1 B2 C1 VDD VSS
.ends

* Black-box entry subcircuit for sg13cmos5l_a21oi_2 abstract view
.subckt sg13cmos5l_a21oi_2 Y A1 A2 B1 VDD VSS
.ends

* Black-box entry subcircuit for sg13cmos5l_nand2b_2 abstract view
.subckt sg13cmos5l_nand2b_2 Y A_N B VDD VSS
.ends

* Black-box entry subcircuit for sg13cmos5l_dlygate4sd3_1 abstract view
.subckt sg13cmos5l_dlygate4sd3_1 X A VDD VSS
.ends

* Black-box entry subcircuit for sg13cmos5l_inv_4 abstract view
.subckt sg13cmos5l_inv_4 Y A VDD VSS
.ends

* Black-box entry subcircuit for sg13cmos5l_or2_1 abstract view
.subckt sg13cmos5l_or2_1 X A B VDD VSS
.ends

* Black-box entry subcircuit for sg13cmos5l_nor4_2 abstract view
.subckt sg13cmos5l_nor4_2 Y A B C D VDD VSS
.ends

* Black-box entry subcircuit for sg13cmos5l_nor3_2 abstract view
.subckt sg13cmos5l_nor3_2 Y A B C VDD VSS
.ends

* Black-box entry subcircuit for sg13cmos5l_and4_1 abstract view
.subckt sg13cmos5l_and4_1 X A B C D VDD VSS
.ends

* Black-box entry subcircuit for sg13cmos5l_nand3b_1 abstract view
.subckt sg13cmos5l_nand3b_1 Y A_N B C VDD VSS
.ends

* Black-box entry subcircuit for RM_IHPSG13_1P_256x32_c2_bm_bist abstract view
.subckt RM_IHPSG13_1P_256x32_c2_bm_bist A_DIN[16] A_DIN[15] A_BIST_DIN[16] A_BIST_DIN[15]
+ A_BM[16] A_BM[15] A_BIST_BM[16] A_BIST_BM[15] A_DOUT[16] A_DOUT[15] VSS VDD VDDARRAY
+ A_DIN[17] A_DIN[14] A_BIST_DIN[17] A_BIST_DIN[14] A_BM[17] A_BM[14] A_BIST_BM[17]
+ A_BIST_BM[14] A_DOUT[17] A_DOUT[14] A_DIN[18] A_DIN[13] A_BIST_DIN[18] A_BIST_DIN[13]
+ A_BM[18] A_BM[13] A_BIST_BM[18] A_BIST_BM[13] A_DOUT[18] A_DOUT[13] A_DIN[19] A_DIN[12]
+ A_BIST_DIN[19] A_BIST_DIN[12] A_BM[19] A_BM[12] A_BIST_BM[19] A_BIST_BM[12] A_DOUT[19]
+ A_DOUT[12] A_DIN[20] A_DIN[11] A_BIST_DIN[20] A_BIST_DIN[11] A_BM[20] A_BM[11] A_BIST_BM[20]
+ A_BIST_BM[11] A_DOUT[20] A_DOUT[11] A_DIN[21] A_DIN[10] A_BIST_DIN[21] A_BIST_DIN[10]
+ A_BM[21] A_BM[10] A_BIST_BM[21] A_BIST_BM[10] A_DOUT[21] A_DOUT[10] A_DIN[22] A_DIN[9]
+ A_BIST_DIN[22] A_BIST_DIN[9] A_BM[22] A_BM[9] A_BIST_BM[22] A_BIST_BM[9] A_DOUT[22]
+ A_DOUT[9] A_DIN[23] A_DIN[8] A_BIST_DIN[23] A_BIST_DIN[8] A_BM[23] A_BM[8] A_BIST_BM[23]
+ A_BIST_BM[8] A_DOUT[23] A_DOUT[8] A_DIN[24] A_DIN[7] A_BIST_DIN[24] A_BIST_DIN[7]
+ A_BM[24] A_BM[7] A_BIST_BM[24] A_BIST_BM[7] A_DOUT[24] A_DOUT[7] A_DIN[25] A_DIN[6]
+ A_BIST_DIN[25] A_BIST_DIN[6] A_BM[25] A_BM[6] A_BIST_BM[25] A_BIST_BM[6] A_DOUT[25]
+ A_DOUT[6] A_DIN[26] A_DIN[5] A_BIST_DIN[26] A_BIST_DIN[5] A_BM[26] A_BM[5] A_BIST_BM[26]
+ A_BIST_BM[5] A_DOUT[26] A_DOUT[5] A_DIN[27] A_DIN[4] A_BIST_DIN[27] A_BIST_DIN[4]
+ A_BM[27] A_BM[4] A_BIST_BM[27] A_BIST_BM[4] A_DOUT[27] A_DOUT[4] A_DIN[28] A_DIN[3]
+ A_BIST_DIN[28] A_BIST_DIN[3] A_BM[28] A_BM[3] A_BIST_BM[28] A_BIST_BM[3] A_DOUT[28]
+ A_DOUT[3] A_DIN[29] A_DIN[2] A_BIST_DIN[29] A_BIST_DIN[2] A_BM[29] A_BM[2] A_BIST_BM[29]
+ A_BIST_BM[2] A_DOUT[29] A_DOUT[2] A_DIN[30] A_DIN[1] A_BIST_DIN[30] A_BIST_DIN[1]
+ A_BM[30] A_BM[1] A_BIST_BM[30] A_BIST_BM[1] A_DOUT[30] A_DOUT[1] A_DIN[31] A_DIN[0]
+ A_BIST_DIN[31] A_BIST_DIN[0] A_BM[31] A_BM[0] A_BIST_BM[31] A_BIST_BM[0] A_DOUT[31]
+ A_DOUT[0] A_ADDR[0] A_BIST_ADDR[0] A_ADDR[1] A_BIST_ADDR[1] A_ADDR[2] A_BIST_ADDR[2]
+ A_ADDR[3] A_BIST_ADDR[3] A_ADDR[4] A_BIST_ADDR[4] A_ADDR[5] A_BIST_ADDR[5] A_ADDR[6]
+ A_BIST_ADDR[6] A_ADDR[7] A_BIST_ADDR[7] A_CLK A_REN A_WEN A_MEN A_DLY A_BIST_EN
+ A_BIST_CLK A_BIST_REN A_BIST_WEN A_BIST_MEN
.ends

* Black-box entry subcircuit for sg13cmos5l_inv_16 abstract view
.subckt sg13cmos5l_inv_16 Y A VDD VSS
.ends

.subckt psum_requant_container VDD VSS act_out[0] act_out[1] act_out[2] act_out[3]
+ act_out[4] act_out[5] act_out[6] act_out[7] bank_A_addr[0] bank_A_addr[1] bank_A_addr[2]
+ bank_A_addr[3] bank_A_addr[4] bank_A_addr[5] bank_A_addr[6] bank_A_addr[7] bank_A_rdata[0]
+ bank_A_rdata[10] bank_A_rdata[11] bank_A_rdata[12] bank_A_rdata[13] bank_A_rdata[14]
+ bank_A_rdata[15] bank_A_rdata[16] bank_A_rdata[17] bank_A_rdata[18] bank_A_rdata[19]
+ bank_A_rdata[1] bank_A_rdata[20] bank_A_rdata[21] bank_A_rdata[22] bank_A_rdata[23]
+ bank_A_rdata[24] bank_A_rdata[25] bank_A_rdata[26] bank_A_rdata[27] bank_A_rdata[28]
+ bank_A_rdata[29] bank_A_rdata[2] bank_A_rdata[30] bank_A_rdata[31] bank_A_rdata[3]
+ bank_A_rdata[4] bank_A_rdata[5] bank_A_rdata[6] bank_A_rdata[7] bank_A_rdata[8]
+ bank_A_rdata[9] bank_A_wdata[0] bank_A_wdata[10] bank_A_wdata[11] bank_A_wdata[12]
+ bank_A_wdata[13] bank_A_wdata[14] bank_A_wdata[15] bank_A_wdata[16] bank_A_wdata[17]
+ bank_A_wdata[18] bank_A_wdata[19] bank_A_wdata[1] bank_A_wdata[20] bank_A_wdata[21]
+ bank_A_wdata[22] bank_A_wdata[23] bank_A_wdata[24] bank_A_wdata[25] bank_A_wdata[26]
+ bank_A_wdata[27] bank_A_wdata[28] bank_A_wdata[29] bank_A_wdata[2] bank_A_wdata[30]
+ bank_A_wdata[31] bank_A_wdata[3] bank_A_wdata[4] bank_A_wdata[5] bank_A_wdata[6]
+ bank_A_wdata[7] bank_A_wdata[8] bank_A_wdata[9] bank_A_we bank_B_addr[0] bank_B_addr[1]
+ bank_B_addr[2] bank_B_addr[3] bank_B_addr[4] bank_B_addr[5] bank_B_addr[6] bank_B_addr[7]
+ bank_B_rdata[0] bank_B_rdata[10] bank_B_rdata[11] bank_B_rdata[12] bank_B_rdata[13]
+ bank_B_rdata[14] bank_B_rdata[15] bank_B_rdata[16] bank_B_rdata[17] bank_B_rdata[18]
+ bank_B_rdata[19] bank_B_rdata[1] bank_B_rdata[20] bank_B_rdata[21] bank_B_rdata[22]
+ bank_B_rdata[23] bank_B_rdata[24] bank_B_rdata[25] bank_B_rdata[26] bank_B_rdata[27]
+ bank_B_rdata[28] bank_B_rdata[29] bank_B_rdata[2] bank_B_rdata[30] bank_B_rdata[31]
+ bank_B_rdata[3] bank_B_rdata[4] bank_B_rdata[5] bank_B_rdata[6] bank_B_rdata[7]
+ bank_B_rdata[8] bank_B_rdata[9] bank_B_wdata[0] bank_B_wdata[10] bank_B_wdata[11]
+ bank_B_wdata[12] bank_B_wdata[13] bank_B_wdata[14] bank_B_wdata[15] bank_B_wdata[16]
+ bank_B_wdata[17] bank_B_wdata[18] bank_B_wdata[19] bank_B_wdata[1] bank_B_wdata[20]
+ bank_B_wdata[21] bank_B_wdata[22] bank_B_wdata[23] bank_B_wdata[24] bank_B_wdata[25]
+ bank_B_wdata[26] bank_B_wdata[27] bank_B_wdata[28] bank_B_wdata[29] bank_B_wdata[2]
+ bank_B_wdata[30] bank_B_wdata[31] bank_B_wdata[3] bank_B_wdata[4] bank_B_wdata[5]
+ bank_B_wdata[6] bank_B_wdata[7] bank_B_wdata[8] bank_B_wdata[9] bank_B_we clk_i
+ psum_lut_en quant_cfg[0] quant_cfg[10] quant_cfg[11] quant_cfg[12] quant_cfg[13]
+ quant_cfg[14] quant_cfg[15] quant_cfg[16] quant_cfg[17] quant_cfg[18] quant_cfg[19]
+ quant_cfg[1] quant_cfg[20] quant_cfg[21] quant_cfg[22] quant_cfg[23] quant_cfg[24]
+ quant_cfg[25] quant_cfg[26] quant_cfg[27] quant_cfg[28] quant_cfg[29] quant_cfg[2]
+ quant_cfg[3] quant_cfg[4] quant_cfg[5] quant_cfg[6] quant_cfg[7] quant_cfg[8] quant_cfg[9]
+ rst_n
XFILLER_67_531 VDD VSS sg13cmos5l_decap_4
XFILLER_67_553 VDD VSS sg13cmos5l_fill_1
XFILLER_79_391 VDD VSS sg13cmos5l_fill_1
XFILLER_36_19 VDD VSS sg13cmos5l_fill_2
XFILLER_67_586 VDD VSS sg13cmos5l_decap_4
X_6914_ _7132_/A _7069_/B _7069_/A _6913_/Y VDD VSS sg13cmos5l_o21ai_1
X_6845_ _6845_/Y _7061_/B _6845_/B VDD VSS sg13cmos5l_nor2_1
X_6776_ _6776_/X _6762_/Y _7006_/B _6775_/Y VDD VSS sg13cmos5l_a21o_1
X_3988_ _4014_/B _3988_/A _3986_/A VDD VSS sg13cmos5l_nor2b_1
X_5727_ _5782_/B _5727_/A _5737_/A VDD VSS sg13cmos5l_xor2_1
X_5658_ _5659_/A _5658_/A _5677_/B VDD VSS sg13cmos5l_xnor2_1
XFILLER_117_11 VDD VSS sg13cmos5l_decap_8
X_5589_ _5590_/B _5589_/A _5588_/Y VDD VSS sg13cmos5l_nor2b_1
X_4609_ _4668_/A _4726_/B _4609_/B VDD VSS sg13cmos5l_nor2_1
Xrebuffer2040 _7642_/A _7097_/A VDD VSS sg13cmos5l_buf_1
X_7328_ _7328_/Y _7328_/A _7328_/B VDD VSS sg13cmos5l_nor2_1
Xrebuffer2051 _6786_/B _6309_/A VDD VSS sg13cmos5l_buf_1
X_7259_ _7542_/B _7259_/A _7557_/A VDD VSS sg13cmos5l_nand2_1
XFILLER_78_807 VDD VSS sg13cmos5l_decap_8
Xrebuffer1361 rebuffer1361/X rebuffer1362/X VDD VSS sg13cmos5l_buf_1
Xrebuffer1350 rebuffer1350/X rebuffer1351/X VDD VSS sg13cmos5l_buf_1
Xrebuffer1394 _6863_/A1 rebuffer1432/X VDD VSS sg13cmos5l_buf_2
Xrebuffer1383 rebuffer1383/X rebuffer1384/X VDD VSS sg13cmos5l_buf_1
Xrebuffer1372 rebuffer1372/X rebuffer1373/X VDD VSS sg13cmos5l_buf_1
XFILLER_58_564 VDD VSS sg13cmos5l_fill_2
XFILLER_85_350 VDD VSS sg13cmos5l_fill_2
XFILLER_45_247 VDD VSS sg13cmos5l_decap_4
XFILLER_41_420 VDD VSS sg13cmos5l_decap_8
XFILLER_42_40 VDD VSS sg13cmos5l_fill_2
XFILLER_68_306 VDD VSS sg13cmos5l_decap_4
XFILLER_69_829 VDD VSS sg13cmos5l_decap_8
XFILLER_77_851 VDD VSS sg13cmos5l_decap_8
XFILLER_76_350 VDD VSS sg13cmos5l_fill_1
XFILLER_37_759 VDD VSS sg13cmos5l_fill_2
XFILLER_49_597 VDD VSS sg13cmos5l_fill_1
XFILLER_76_383 VDD VSS sg13cmos5l_fill_1
XFILLER_52_707 VDD VSS sg13cmos5l_decap_8
X_4960_ _5030_/A _4958_/Y _4899_/B _4959_/Y VDD VSS sg13cmos5l_o21ai_1
X_4891_ _4939_/A _4947_/B _4825_/A _4890_/Y VDD VSS sg13cmos5l_a21o_1
X_6630_ _6631_/A _6630_/A _6630_/B VDD VSS sg13cmos5l_nor2_1
X_6561_ _6561_/Y _6567_/A _6561_/B VDD VSS sg13cmos5l_nand2_1
X_5512_ _5512_/Y _5512_/A _5512_/B VDD VSS sg13cmos5l_nor2_1
X_6492_ _6508_/A _6492_/A _6491_/A VDD VSS sg13cmos5l_nor2b_2
X_5374_ _5374_/X _5374_/A _5374_/B VDD VSS sg13cmos5l_and2_1
X_7113_ _7264_/B _7112_/B _6831_/A _7112_/Y VDD VSS sg13cmos5l_o21ai_1
X_4325_ _4328_/A _3972_/A _4326_/A _3976_/B VDD VSS sg13cmos5l_a21oi_1
Xfanout116 _5982_/A _6052_/B VDD VSS sg13cmos5l_buf_1
XFILLER_87_626 VDD VSS sg13cmos5l_decap_8
X_4256_ _4289_/B _4210_/A _4210_/B _4255_/Y VDD VSS sg13cmos5l_a21o_1
XFILLER_86_147 VDD VSS sg13cmos5l_fill_1
XFILLER_67_361 VDD VSS sg13cmos5l_decap_4
XFILLER_68_873 VDD VSS sg13cmos5l_decap_8
X_4187_ _4188_/A _4187_/A _4234_/A VDD VSS sg13cmos5l_xnor2_1
XFILLER_83_810 VDD VSS sg13cmos5l_decap_8
XFILLER_55_556 VDD VSS sg13cmos5l_decap_4
XFILLER_83_887 VDD VSS sg13cmos5l_decap_8
XFILLER_42_239 VDD VSS sg13cmos5l_decap_4
XFILLER_51_740 VDD VSS sg13cmos5l_decap_8
XFILLER_51_762 VDD VSS sg13cmos5l_fill_1
X_6828_ _6829_/B _6826_/Y _6827_/Y _6957_/S VDD VSS sg13cmos5l_mux2_1
X_6759_ _6759_/X _6759_/A _6918_/B VDD VSS sg13cmos5l_and2_1
XFILLER_5_4 VDD VSS sg13cmos5l_decap_8
XFILLER_59_884 VDD VSS sg13cmos5l_decap_8
XFILLER_77_169 VDD VSS sg13cmos5l_decap_8
XFILLER_58_372 VDD VSS sg13cmos5l_decap_8
XFILLER_74_843 VDD VSS sg13cmos5l_decap_8
XFILLER_73_342 VDD VSS sg13cmos5l_decap_8
XFILLER_85_191 VDD VSS sg13cmos5l_decap_8
XFILLER_53_50 VDD VSS sg13cmos5l_decap_8
XFILLER_42_795 VDD VSS sg13cmos5l_decap_8
XFILLER_52_6 VDD VSS sg13cmos5l_fill_1
X_5090_ _5162_/B _5157_/A _5090_/B VDD VSS sg13cmos5l_xnor2_1
X_4110_ _4112_/A _4110_/A _4110_/B VDD VSS sg13cmos5l_nand2_1
XFILLER_56_309 VDD VSS sg13cmos5l_decap_8
X_4041_ _7664_/D _4100_/A _4100_/B VDD VSS sg13cmos5l_xor2_1
XFILLER_84_618 VDD VSS sg13cmos5l_decap_8
XFILLER_65_843 VDD VSS sg13cmos5l_decap_8
XFILLER_77_681 VDD VSS sg13cmos5l_decap_8
XFILLER_64_342 VDD VSS sg13cmos5l_decap_8
X_5992_ _5993_/B _5992_/A _6019_/A VDD VSS sg13cmos5l_xnor2_1
XFILLER_52_548 VDD VSS sg13cmos5l_fill_1
XFILLER_80_857 VDD VSS sg13cmos5l_decap_8
X_7662_ _7662_/Q _7679_/CLK _7662_/D place748/X VDD VSS sg13cmos5l_dfrbpq_1
X_6613_ _6615_/A _6613_/A VDD VSS sg13cmos5l_inv_1
X_4874_ _4924_/A _5442_/A _4874_/B VDD VSS sg13cmos5l_xnor2_1
X_7593_ _7596_/B _7628_/A _7593_/B VDD VSS sg13cmos5l_nand2_1
X_6544_ _6554_/A _6544_/A _6552_/C VDD VSS sg13cmos5l_nand2_1
X_6475_ _6475_/Y _6476_/B _6476_/A VDD VSS sg13cmos5l_nor2_1
X_5426_ _5542_/B _5426_/A _5426_/B VDD VSS sg13cmos5l_nand2_1
X_5357_ _5358_/A _5357_/A _5357_/B VDD VSS sg13cmos5l_xor2_1
X_5288_ _5351_/A _5288_/A _5288_/B VDD VSS sg13cmos5l_nand2_1
X_4308_ _4309_/B _3964_/C _4203_/A _3965_/B _4686_/B2 VDD VSS sg13cmos5l_a22oi_1
Xwire1006 _4588_/A wire1006/A VDD VSS sg13cmos5l_buf_2
X_7027_ _7027_/Y _7027_/A VDD VSS sg13cmos5l_inv_1
X_4239_ _4239_/Y _4243_/B _4243_/C VDD VSS sg13cmos5l_nand2_1
XFILLER_75_618 VDD VSS sg13cmos5l_fill_2
XFILLER_68_692 VDD VSS sg13cmos5l_fill_1
XFILLER_56_854 VDD VSS sg13cmos5l_decap_8
XFILLER_55_375 VDD VSS sg13cmos5l_decap_8
XFILLER_83_684 VDD VSS sg13cmos5l_decap_8
XFILLER_71_879 VDD VSS sg13cmos5l_decap_8
Xbank_A_sram.gen_ihp_256x32.u_sram_256x32_1180 bank_A_sram.gen_ihp_256x32.u_sram_256x32/A_BM[5]
+ VDD VSS sg13cmos5l_tiehi
Xbank_A_sram.gen_ihp_256x32.u_sram_256x32_1191 bank_A_sram.gen_ihp_256x32.u_sram_256x32/A_BM[16]
+ VDD VSS sg13cmos5l_tiehi
XFILLER_48_50 VDD VSS sg13cmos5l_fill_2
XFILLER_66_607 VDD VSS sg13cmos5l_fill_1
XFILLER_47_865 VDD VSS sg13cmos5l_decap_8
XFILLER_58_180 VDD VSS sg13cmos5l_decap_8
XFILLER_46_353 VDD VSS sg13cmos5l_fill_1
XFILLER_62_802 VDD VSS sg13cmos5l_fill_1
XFILLER_62_824 VDD VSS sg13cmos5l_decap_8
XFILLER_80_109 VDD VSS sg13cmos5l_fill_1
XFILLER_73_183 VDD VSS sg13cmos5l_fill_2
X_4590_ _4590_/Y _4590_/A _4590_/B VDD VSS sg13cmos5l_nor2_1
XFILLER_80_70 VDD VSS sg13cmos5l_fill_1
X_6260_ _6275_/A _6260_/A _7712_/Q VDD VSS sg13cmos5l_nand2_1
Xrebuffer1927 rebuffer1927/X rebuffer1928/X VDD VSS sg13cmos5l_buf_1
Xrebuffer1916 rebuffer1916/X rebuffer1917/X VDD VSS sg13cmos5l_buf_1
Xrebuffer1905 _4294_/A _4351_/B VDD VSS sg13cmos5l_buf_1
X_6191_ _6191_/Y _6209_/A1 _6189_/Y _6190_/Y VDD VSS sg13cmos5l_a21oi_1
X_5211_ _5212_/B _5266_/A _5266_/B VDD VSS sg13cmos5l_xor2_1
Xrebuffer1949 rebuffer1949/X rebuffer1950/X VDD VSS sg13cmos5l_buf_1
Xrebuffer1938 rebuffer1938/X rebuffer1939/X VDD VSS sg13cmos5l_buf_1
XFILLER_85_916 VDD VSS sg13cmos5l_fill_2
XFILLER_85_905 VDD VSS sg13cmos5l_decap_8
XFILLER_38_821 VDD VSS sg13cmos5l_decap_8
X_5073_ _5086_/A _5141_/A _5073_/B VDD VSS sg13cmos5l_xnor2_1
XFILLER_84_426 VDD VSS sg13cmos5l_fill_2
XFILLER_65_651 VDD VSS sg13cmos5l_fill_1
X_4024_ _4025_/B _4172_/A _4086_/B _4024_/C VDD VSS sg13cmos5l_nor3_1
XFILLER_38_898 VDD VSS sg13cmos5l_decap_8
XFILLER_53_846 VDD VSS sg13cmos5l_decap_8
XFILLER_80_632 VDD VSS sg13cmos5l_decap_4
X_5975_ _5975_/Y _5975_/A _5956_/A VDD VSS sg13cmos5l_nor2b_1
XFILLER_52_389 VDD VSS sg13cmos5l_fill_2
X_7714_ _7714_/Q clkload2/A _7714_/D place745/X VDD VSS sg13cmos5l_dfrbpq_1
X_4926_ _4927_/B _4926_/A _4982_/A VDD VSS sg13cmos5l_xnor2_1
XFILLER_80_698 VDD VSS sg13cmos5l_decap_8
X_7645_ _7724_/D _7645_/A _7658_/B VDD VSS sg13cmos5l_nand2_2
X_4857_ _4904_/A _4967_/A _4915_/B VDD VSS sg13cmos5l_xnor2_1
X_7576_ _7623_/B _7576_/A _7576_/B VDD VSS sg13cmos5l_xnor2_1
X_4788_ _4847_/A _4728_/B _4729_/A _4787_/Y VDD VSS sg13cmos5l_o21ai_1
X_6458_ _6461_/A _6456_/Y _6468_/A VDD VSS sg13cmos5l_nand2b_1
X_6389_ _6400_/A _6389_/A _6389_/B VDD VSS sg13cmos5l_nand2_1
X_5409_ _5425_/A _5409_/A _5409_/B VDD VSS sg13cmos5l_nand2_1
XFILLER_88_710 VDD VSS sg13cmos5l_fill_1
XFILLER_125_11 VDD VSS sg13cmos5l_decap_8
XFILLER_88_721 VDD VSS sg13cmos5l_fill_2
XFILLER_88_765 VDD VSS sg13cmos5l_fill_1
XFILLER_87_242 VDD VSS sg13cmos5l_decap_8
XFILLER_87_286 VDD VSS sg13cmos5l_decap_8
XFILLER_75_448 VDD VSS sg13cmos5l_decap_8
XFILLER_44_813 VDD VSS sg13cmos5l_decap_8
XFILLER_71_643 VDD VSS sg13cmos5l_fill_1
XFILLER_59_82 VDD VSS sg13cmos5l_decap_8
XFILLER_67_916 VDD VSS sg13cmos5l_fill_2
XFILLER_79_798 VDD VSS sg13cmos5l_decap_8
XFILLER_78_286 VDD VSS sg13cmos5l_fill_1
XFILLER_78_264 VDD VSS sg13cmos5l_fill_2
XFILLER_53_109 VDD VSS sg13cmos5l_decap_4
XFILLER_81_418 VDD VSS sg13cmos5l_fill_2
XFILLER_75_92 VDD VSS sg13cmos5l_decap_4
XFILLER_50_827 VDD VSS sg13cmos5l_decap_8
X_5760_ _5761_/B _5801_/B1 _5981_/A2 _5760_/B1 _5981_/B2 VDD VSS sg13cmos5l_a22oi_1
X_5691_ _5739_/A _5639_/B _5639_/A _5690_/X VDD VSS sg13cmos5l_a21oi_1
X_4711_ _4712_/B _4711_/A _4779_/B VDD VSS sg13cmos5l_xor2_1
X_4642_ _4643_/B _4697_/B1 _5009_/A2 _4642_/B1 _4642_/B2 VDD VSS sg13cmos5l_a22oi_1
X_7361_ _7368_/A _7361_/A _7513_/B _7514_/B VDD VSS sg13cmos5l_nand3_1
X_4573_ _4580_/A _5060_/A _4573_/B VDD VSS sg13cmos5l_xnor2_1
X_7292_ _7554_/B _7557_/A _7307_/A VDD VSS sg13cmos5l_xnor2_1
X_6312_ _6611_/C _6800_/A _6321_/B _6548_/C VDD VSS sg13cmos5l_nor3_1
X_6243_ _6698_/A _7711_/Q VDD VSS sg13cmos5l_inv_2
XFILLER_58_916 VDD VSS sg13cmos5l_fill_2
X_6174_ _6176_/A _6175_/B _6175_/C _6175_/A VDD VSS sg13cmos5l_nor3_1
XFILLER_85_702 VDD VSS sg13cmos5l_decap_8
X_5125_ _5126_/B _5125_/A _5175_/A VDD VSS sg13cmos5l_xnor2_1
XFILLER_73_908 VDD VSS sg13cmos5l_decap_8
X_5056_ _5057_/B _5056_/A _5113_/A VDD VSS sg13cmos5l_xnor2_1
XFILLER_85_779 VDD VSS sg13cmos5l_decap_8
X_4007_ _4008_/B wire989/X _4175_/A2 _4162_/A1 _4175_/B2 VDD VSS sg13cmos5l_a22oi_1
XFILLER_37_172 VDD VSS sg13cmos5l_decap_8
XFILLER_38_695 VDD VSS sg13cmos5l_decap_8
XFILLER_52_142 VDD VSS sg13cmos5l_decap_8
XFILLER_41_838 VDD VSS sg13cmos5l_decap_8
X_5958_ _5999_/A _5878_/A _5947_/B _5957_/Y VDD VSS sg13cmos5l_o21ai_1
X_4909_ _4974_/A _4909_/A _4914_/A VDD VSS sg13cmos5l_xnor2_1
X_5889_ _5936_/A _5889_/A _5889_/B _5889_/C VDD VSS sg13cmos5l_nand3_1
X_7628_ _7629_/D _7628_/A _7592_/C VDD VSS sg13cmos5l_nor2b_1
X_7559_ _7616_/A _7559_/A _7559_/B VDD VSS sg13cmos5l_xnor2_1
XFILLER_88_540 VDD VSS sg13cmos5l_fill_1
XFILLER_75_278 VDD VSS sg13cmos5l_decap_8
XFILLER_44_621 VDD VSS sg13cmos5l_fill_2
XFILLER_56_470 VDD VSS sg13cmos5l_decap_4
XFILLER_71_451 VDD VSS sg13cmos5l_decap_8
XFILLER_40_893 VDD VSS sg13cmos5l_decap_8
XANTENNA_5 input822/X VDD VSS sg13cmos5l_antennanp
XFILLER_82_727 VDD VSS sg13cmos5l_decap_8
XFILLER_66_289 VDD VSS sg13cmos5l_fill_1
X_6930_ _6931_/A _6934_/S _6872_/A _6929_/Y VDD VSS sg13cmos5l_o21ai_1
XFILLER_81_226 VDD VSS sg13cmos5l_fill_2
X_6861_ _6862_/B _6861_/A _6861_/B VDD VSS sg13cmos5l_nand2_1
XFILLER_62_473 VDD VSS sg13cmos5l_fill_2
X_6792_ _6792_/Y _6974_/B _6970_/A VDD VSS sg13cmos5l_nor2_1
X_5812_ _5876_/B _5810_/B _5811_/A _5810_/Y _5811_/Y VDD VSS sg13cmos5l_a22oi_1
XFILLER_50_668 VDD VSS sg13cmos5l_decap_8
XFILLER_62_495 VDD VSS sg13cmos5l_fill_1
X_5743_ _5773_/A _5741_/Y _5721_/A _5742_/Y VDD VSS sg13cmos5l_a21oi_1
X_5674_ _5736_/A _5674_/A _5674_/B _5674_/C VDD VSS sg13cmos5l_nand3_1
X_7413_ _7414_/C _7413_/A _7413_/B VDD VSS sg13cmos5l_nor2_1
X_4625_ _4626_/B _4625_/A _4672_/A VDD VSS sg13cmos5l_xnor2_1
X_7344_ _7344_/Y _7130_/Y _7350_/A2 _7328_/B VDD VSS sg13cmos5l_a21oi_1
X_4556_ _4604_/A _4556_/A _4615_/B VDD VSS sg13cmos5l_xnor2_1
X_4487_ _4556_/A _4494_/B VDD VSS sg13cmos5l_buf_1
X_6226_ _6226_/Y _6227_/A _6204_/Y _6225_/Y VDD VSS sg13cmos5l_o21ai_1
XFILLER_66_17 VDD VSS sg13cmos5l_fill_1
X_6157_ _7704_/D _6157_/A _6157_/B VDD VSS sg13cmos5l_xor2_1
X_5108_ _5234_/B _5108_/A _5108_/B VDD VSS sg13cmos5l_and2_1
XFILLER_58_779 VDD VSS sg13cmos5l_decap_4
X_6088_ _6120_/A _6108_/B _6088_/B VDD VSS sg13cmos5l_xnor2_1
XFILLER_85_576 VDD VSS sg13cmos5l_decap_8
XFILLER_38_492 VDD VSS sg13cmos5l_decap_8
XFILLER_57_289 VDD VSS sg13cmos5l_fill_2
X_5039_ _7682_/D _5105_/B _5039_/B VDD VSS sg13cmos5l_xor2_1
XFILLER_53_440 VDD VSS sg13cmos5l_fill_2
XFILLER_82_27 VDD VSS sg13cmos5l_fill_2
XFILLER_31_20 VDD VSS sg13cmos5l_fill_1
XFILLER_48_201 VDD VSS sg13cmos5l_decap_8
XFILLER_76_532 VDD VSS sg13cmos5l_decap_8
XFILLER_48_267 VDD VSS sg13cmos5l_decap_4
XFILLER_63_259 VDD VSS sg13cmos5l_fill_1
XFILLER_44_462 VDD VSS sg13cmos5l_decap_4
X_4410_ _4475_/B _4410_/A _4476_/B VDD VSS sg13cmos5l_xnor2_1
X_5390_ _5438_/A _5341_/B _5341_/A _5389_/Y VDD VSS sg13cmos5l_a21oi_1
X_4341_ _4343_/C _4357_/A _4356_/A VDD VSS sg13cmos5l_xnor2_1
X_7060_ _7060_/Y _7058_/Y _7301_/A2 _7059_/Y VDD VSS sg13cmos5l_a21oi_1
X_4272_ _4282_/A _4322_/A _4272_/B VDD VSS sg13cmos5l_xnor2_1
XFILLER_87_808 VDD VSS sg13cmos5l_decap_8
XFILLER_67_510 VDD VSS sg13cmos5l_decap_8
X_6011_ _6012_/B _5966_/B _6168_/A _6010_/X VDD VSS sg13cmos5l_a21o_1
XFILLER_67_543 VDD VSS sg13cmos5l_fill_2
XFILLER_55_727 VDD VSS sg13cmos5l_decap_8
XFILLER_54_237 VDD VSS sg13cmos5l_decap_8
X_6913_ _6913_/Y _7052_/A _7002_/B VDD VSS sg13cmos5l_nand2_1
XFILLER_63_782 VDD VSS sg13cmos5l_fill_2
X_6844_ _6845_/B _6841_/X _6941_/B _6843_/X VDD VSS sg13cmos5l_a21oi_1
X_6775_ _6775_/Y _7006_/B _6775_/B VDD VSS sg13cmos5l_nor2_1
X_3987_ _4015_/B _3987_/A _3987_/B VDD VSS sg13cmos5l_nor2_1
X_5726_ _5737_/A _5775_/A _5726_/B VDD VSS sg13cmos5l_xnor2_1
X_5657_ _5677_/B _5657_/A _5657_/B VDD VSS sg13cmos5l_xnor2_1
X_5588_ _5588_/Y _5588_/A _5709_/B VDD VSS sg13cmos5l_nand2_1
X_4608_ _4609_/B _4550_/A _4551_/A _4607_/Y VDD VSS sg13cmos5l_a21oi_1
Xrebuffer2030 _7315_/A2 _6892_/Y VDD VSS sg13cmos5l_buf_1
X_7327_ _7328_/A _7327_/A _7327_/B VDD VSS sg13cmos5l_nor2_1
X_4539_ _4539_/X _4539_/A _4539_/B VDD VSS sg13cmos5l_and2_1
Xrebuffer2041 _6798_/B _6299_/A VDD VSS sg13cmos5l_buf_1
Xrebuffer2052 _6359_/B _6368_/B VDD VSS sg13cmos5l_buf_1
X_7258_ _7260_/A _7258_/A _7542_/A _7543_/B VDD VSS sg13cmos5l_nand3_1
XFILLER_77_16 VDD VSS sg13cmos5l_fill_1
Xrebuffer1362 rebuffer1362/X rebuffer1363/X VDD VSS sg13cmos5l_buf_1
Xrebuffer1351 rebuffer1351/X rebuffer1352/X VDD VSS sg13cmos5l_buf_1
Xrebuffer1340 rebuffer1340/X rebuffer1341/X VDD VSS sg13cmos5l_buf_1
X_6209_ _6209_/Y _6209_/A1 _6207_/Y _6208_/Y VDD VSS sg13cmos5l_a21oi_1
Xrebuffer1395 _7539_/A1 _7217_/A VDD VSS sg13cmos5l_buf_1
Xrebuffer1384 rebuffer1384/X rebuffer1385/X VDD VSS sg13cmos5l_buf_1
Xrebuffer1373 rebuffer1373/X rebuffer1374/X VDD VSS sg13cmos5l_buf_1
XFILLER_46_716 VDD VSS sg13cmos5l_decap_8
XFILLER_86_885 VDD VSS sg13cmos5l_decap_8
XFILLER_26_20 VDD VSS sg13cmos5l_fill_1
XFILLER_42_900 VDD VSS sg13cmos5l_decap_8
XFILLER_69_808 VDD VSS sg13cmos5l_decap_8
XFILLER_49_521 VDD VSS sg13cmos5l_fill_2
XFILLER_49_532 VDD VSS sg13cmos5l_fill_1
XFILLER_77_830 VDD VSS sg13cmos5l_decap_8
XFILLER_49_554 VDD VSS sg13cmos5l_decap_8
XFILLER_67_82 VDD VSS sg13cmos5l_fill_2
XFILLER_64_513 VDD VSS sg13cmos5l_fill_2
XFILLER_64_546 VDD VSS sg13cmos5l_fill_1
X_4890_ _4890_/Y _4890_/A _4890_/B VDD VSS sg13cmos5l_nor2_1
X_6560_ _6567_/A _6560_/A _6560_/B VDD VSS sg13cmos5l_nor2_2
XFILLER_73_2 VDD VSS sg13cmos5l_fill_1
X_5511_ _5566_/B _5511_/A _5511_/B VDD VSS sg13cmos5l_xor2_1
X_6491_ _6491_/Y _6491_/A _6492_/A VDD VSS sg13cmos5l_nor2b_1
X_5442_ _5897_/B _5442_/A VDD VSS sg13cmos5l_buf_1
XFILLER_59_0 VDD VSS sg13cmos5l_fill_1
X_5373_ _5376_/A _5429_/S _5373_/B VDD VSS sg13cmos5l_xnor2_1
X_7112_ _7112_/Y _7112_/A _7112_/B VDD VSS sg13cmos5l_nand2_1
XFILLER_59_318 VDD VSS sg13cmos5l_decap_4
X_7043_ _7097_/A _7043_/A _7638_/B VDD VSS sg13cmos5l_nand2_2
X_4255_ _4255_/Y _4255_/A _4211_/B VDD VSS sg13cmos5l_nor2b_1
XFILLER_68_852 VDD VSS sg13cmos5l_decap_8
X_4186_ _4187_/A _4186_/A _4235_/A VDD VSS sg13cmos5l_xnor2_1
XFILLER_83_866 VDD VSS sg13cmos5l_decap_8
XFILLER_42_218 VDD VSS sg13cmos5l_fill_1
XFILLER_70_527 VDD VSS sg13cmos5l_decap_4
Xplace590 _7294_/B _7144_/B VDD VSS sg13cmos5l_buf_1
X_6827_ _6827_/Y _6827_/A _6827_/B VDD VSS sg13cmos5l_xnor2_1
X_6689_ _6696_/A _6689_/A _6690_/A VDD VSS sg13cmos5l_nor2b_1
X_5709_ _5711_/A _5710_/A _5709_/B VDD VSS sg13cmos5l_nand2b_1
XFILLER_78_616 VDD VSS sg13cmos5l_fill_2
XFILLER_59_863 VDD VSS sg13cmos5l_decap_8
XFILLER_77_148 VDD VSS sg13cmos5l_fill_2
XFILLER_37_30 VDD VSS sg13cmos5l_fill_2
XFILLER_74_822 VDD VSS sg13cmos5l_decap_8
XFILLER_86_682 VDD VSS sg13cmos5l_decap_8
XFILLER_37_74 VDD VSS sg13cmos5l_fill_1
XFILLER_73_321 VDD VSS sg13cmos5l_fill_2
XFILLER_85_181 VDD VSS sg13cmos5l_fill_2
XFILLER_61_516 VDD VSS sg13cmos5l_fill_1
XFILLER_73_365 VDD VSS sg13cmos5l_fill_2
XFILLER_73_376 VDD VSS sg13cmos5l_fill_1
XFILLER_74_899 VDD VSS sg13cmos5l_decap_8
XFILLER_42_730 VDD VSS sg13cmos5l_fill_1
XFILLER_41_240 VDD VSS sg13cmos5l_decap_4
XFILLER_42_774 VDD VSS sg13cmos5l_decap_8
XFILLER_41_262 VDD VSS sg13cmos5l_decap_8
XFILLER_53_95 VDD VSS sg13cmos5l_decap_8
XFILLER_68_115 VDD VSS sg13cmos5l_decap_8
XFILLER_69_638 VDD VSS sg13cmos5l_fill_2
XFILLER_69_649 VDD VSS sg13cmos5l_decap_8
X_4040_ _4100_/B _4040_/A _4102_/B VDD VSS sg13cmos5l_xor2_1
XFILLER_77_660 VDD VSS sg13cmos5l_decap_8
XFILLER_37_524 VDD VSS sg13cmos5l_decap_8
XFILLER_49_384 VDD VSS sg13cmos5l_fill_1
XFILLER_64_310 VDD VSS sg13cmos5l_decap_8
XFILLER_65_822 VDD VSS sg13cmos5l_decap_8
XFILLER_37_535 VDD VSS sg13cmos5l_fill_1
XFILLER_52_505 VDD VSS sg13cmos5l_fill_1
XFILLER_64_365 VDD VSS sg13cmos5l_decap_8
XFILLER_65_899 VDD VSS sg13cmos5l_decap_8
X_5991_ _6019_/A _5991_/A _5991_/B VDD VSS sg13cmos5l_nor2_1
XFILLER_80_836 VDD VSS sg13cmos5l_decap_8
XFILLER_64_398 VDD VSS sg13cmos5l_fill_2
X_4942_ _4953_/A _5141_/A _4942_/B VDD VSS sg13cmos5l_xnor2_1
X_7661_ _7661_/Q _7679_/CLK _7661_/D place748/X VDD VSS sg13cmos5l_dfrbpq_1
X_6612_ _6612_/Y _6613_/A _6614_/A VDD VSS sg13cmos5l_nor2_1
X_4873_ _4874_/B _5430_/B1 _5322_/A2 _4873_/B1 _5322_/B2 VDD VSS sg13cmos5l_a22oi_1
X_7592_ _7593_/B _7626_/B _7592_/B _7592_/C VDD VSS sg13cmos5l_nor3_1
X_6543_ _6544_/A _6549_/B _6549_/A VDD VSS sg13cmos5l_xnor2_1
X_6474_ _6476_/B _6483_/A _6611_/C VDD VSS sg13cmos5l_nand2_1
X_5425_ _5426_/B _5425_/A _5425_/B VDD VSS sg13cmos5l_nand2_1
X_5356_ _5357_/B _5547_/A _5418_/B VDD VSS sg13cmos5l_xnor2_1
XFILLER_87_402 VDD VSS sg13cmos5l_fill_2
X_5287_ _5288_/B _5215_/A _5287_/B VDD VSS sg13cmos5l_nand2b_1
X_4307_ _4340_/A _4363_/B _4360_/B VDD VSS sg13cmos5l_xnor2_1
XFILLER_56_800 VDD VSS sg13cmos5l_fill_1
Xwire1018 _4520_/B1 wire1018/A VDD VSS sg13cmos5l_buf_2
X_7026_ _7027_/A _6886_/A _6875_/X _7071_/B VDD VSS sg13cmos5l_mux2_1
X_4238_ _4238_/Y _4234_/Y _4192_/A _4243_/A VDD VSS sg13cmos5l_a21oi_1
XFILLER_87_468 VDD VSS sg13cmos5l_decap_8
XFILLER_56_833 VDD VSS sg13cmos5l_decap_8
XFILLER_68_671 VDD VSS sg13cmos5l_fill_2
XFILLER_74_107 VDD VSS sg13cmos5l_fill_1
XFILLER_67_192 VDD VSS sg13cmos5l_decap_4
XFILLER_74_39 VDD VSS sg13cmos5l_decap_4
XFILLER_43_516 VDD VSS sg13cmos5l_fill_2
XFILLER_83_663 VDD VSS sg13cmos5l_decap_8
XFILLER_71_858 VDD VSS sg13cmos5l_decap_8
XFILLER_82_184 VDD VSS sg13cmos5l_fill_2
XFILLER_82_173 VDD VSS sg13cmos5l_fill_2
XFILLER_70_368 VDD VSS sg13cmos5l_decap_4
XFILLER_51_593 VDD VSS sg13cmos5l_fill_1
XFILLER_79_903 VDD VSS sg13cmos5l_decap_8
XFILLER_78_402 VDD VSS sg13cmos5l_fill_2
Xbank_A_sram.gen_ihp_256x32.u_sram_256x32_1181 bank_A_sram.gen_ihp_256x32.u_sram_256x32/A_BM[6]
+ VDD VSS sg13cmos5l_tiehi
Xbank_A_sram.gen_ihp_256x32.u_sram_256x32_1192 bank_A_sram.gen_ihp_256x32.u_sram_256x32/A_BM[17]
+ VDD VSS sg13cmos5l_tiehi
XFILLER_78_468 VDD VSS sg13cmos5l_fill_2
XFILLER_47_800 VDD VSS sg13cmos5l_fill_1
XFILLER_0_14 VDD VSS sg13cmos5l_decap_8
XFILLER_47_844 VDD VSS sg13cmos5l_decap_8
XFILLER_9_12 VDD VSS sg13cmos5l_decap_8
X_5210_ _5266_/B _5586_/A _5210_/B VDD VSS sg13cmos5l_xnor2_1
Xrebuffer1928 rebuffer1928/X rebuffer1929/X VDD VSS sg13cmos5l_buf_1
Xrebuffer1917 rebuffer1917/X rebuffer1918/X VDD VSS sg13cmos5l_buf_1
Xrebuffer1906 _4548_/B_N _4547_/Y VDD VSS sg13cmos5l_buf_1
X_6190_ _6190_/Y _6205_/A _6190_/B VDD VSS sg13cmos5l_nor2_1
Xrebuffer1939 rebuffer1939/X rebuffer1940/X VDD VSS sg13cmos5l_buf_1
X_5141_ _5152_/A _5141_/A _5141_/B VDD VSS sg13cmos5l_xnor2_1
XFILLER_57_608 VDD VSS sg13cmos5l_decap_4
X_5072_ _5073_/B _4825_/A _5514_/A2 _4766_/A _5140_/B2 VDD VSS sg13cmos5l_a22oi_1
XFILLER_38_800 VDD VSS sg13cmos5l_decap_8
XFILLER_56_107 VDD VSS sg13cmos5l_fill_1
X_4023_ _4024_/C _4023_/A VDD VSS sg13cmos5l_inv_1
XFILLER_65_630 VDD VSS sg13cmos5l_decap_4
XFILLER_38_877 VDD VSS sg13cmos5l_decap_8
XFILLER_53_825 VDD VSS sg13cmos5l_decap_8
XFILLER_37_387 VDD VSS sg13cmos5l_fill_2
XFILLER_64_195 VDD VSS sg13cmos5l_fill_2
X_7713_ _7713_/Q clkload2/A _7713_/D place745/X VDD VSS sg13cmos5l_dfrbpq_1
X_5974_ _6036_/A _5955_/B _5955_/A _5973_/Y VDD VSS sg13cmos5l_a21oi_1
XFILLER_80_677 VDD VSS sg13cmos5l_decap_8
X_4925_ _4982_/A _4881_/B _4881_/A _4924_/X VDD VSS sg13cmos5l_a21oi_1
X_7644_ _7645_/A _7657_/A _7644_/B VDD VSS sg13cmos5l_nand2_2
X_4856_ _4915_/B _4806_/B _4806_/A _4855_/Y VDD VSS sg13cmos5l_a21oi_1
X_7575_ _7576_/B _7575_/A _7575_/B VDD VSS sg13cmos5l_nand2_1
X_6526_ _6529_/A _6534_/B _6534_/A VDD VSS sg13cmos5l_xnor2_1
X_4787_ _4787_/Y _4724_/A _4726_/X _4724_/B VDD VSS sg13cmos5l_o21ai_1
XFILLER_69_28 VDD VSS sg13cmos5l_fill_1
X_6457_ _6468_/A _6457_/A _6457_/B _6457_/C VDD VSS sg13cmos5l_nand3_1
X_6388_ _6388_/Y _6389_/B _6389_/A VDD VSS sg13cmos5l_nor2_1
X_5408_ _5409_/B _5344_/A _5408_/B VDD VSS sg13cmos5l_nand2b_1
X_5339_ _5389_/B _5586_/A _5339_/B VDD VSS sg13cmos5l_xnor2_1
XFILLER_88_755 VDD VSS sg13cmos5l_fill_2
XFILLER_76_917 VDD VSS sg13cmos5l_fill_1
XFILLER_56_641 VDD VSS sg13cmos5l_fill_2
X_7009_ _7010_/A _7326_/A _7111_/A _7326_/B VDD VSS sg13cmos5l_nand3_1
XFILLER_83_460 VDD VSS sg13cmos5l_fill_1
XFILLER_43_324 VDD VSS sg13cmos5l_decap_8
XFILLER_71_633 VDD VSS sg13cmos5l_fill_1
XFILLER_34_20 VDD VSS sg13cmos5l_fill_1
XFILLER_44_869 VDD VSS sg13cmos5l_decap_8
XFILLER_70_143 VDD VSS sg13cmos5l_decap_8
XFILLER_52_880 VDD VSS sg13cmos5l_decap_8
XFILLER_50_52 VDD VSS sg13cmos5l_decap_4
XFILLER_50_63 VDD VSS sg13cmos5l_decap_4
XFILLER_78_210 VDD VSS sg13cmos5l_fill_2
XFILLER_79_777 VDD VSS sg13cmos5l_decap_8
XFILLER_82_909 VDD VSS sg13cmos5l_decap_8
XFILLER_62_600 VDD VSS sg13cmos5l_fill_1
XFILLER_81_408 VDD VSS sg13cmos5l_fill_2
XFILLER_46_173 VDD VSS sg13cmos5l_decap_8
XFILLER_47_685 VDD VSS sg13cmos5l_decap_4
XFILLER_61_132 VDD VSS sg13cmos5l_fill_1
X_5690_ _5690_/X _5690_/A _5690_/B VDD VSS sg13cmos5l_and2_1
X_4710_ _4779_/B _4710_/A _4710_/B VDD VSS sg13cmos5l_xor2_1
X_7360_ _7514_/B _7360_/A _7360_/B VDD VSS sg13cmos5l_nand2_1
X_4572_ _4573_/B _4739_/B1 _4930_/A2 _4738_/A1 _4686_/B2 VDD VSS sg13cmos5l_a22oi_1
X_7291_ _7307_/A _6630_/A _7284_/Y _7290_/Y VDD VSS sg13cmos5l_o21ai_1
X_6311_ _6548_/C _6976_/B _6807_/A VDD VSS sg13cmos5l_nand2_1
XFILLER_41_0 VDD VSS sg13cmos5l_fill_2
X_6173_ _6177_/A _6165_/A _6173_/B VDD VSS sg13cmos5l_nand2b_1
XFILLER_69_287 VDD VSS sg13cmos5l_fill_1
X_5124_ _5175_/A _5069_/B _5069_/A _5123_/X VDD VSS sg13cmos5l_a21oi_1
XFILLER_38_641 VDD VSS sg13cmos5l_fill_2
X_5055_ _5113_/A _5006_/B _5006_/A _5054_/X VDD VSS sg13cmos5l_a21oi_1
XFILLER_85_758 VDD VSS sg13cmos5l_decap_8
XFILLER_84_213 VDD VSS sg13cmos5l_fill_2
XFILLER_37_140 VDD VSS sg13cmos5l_decap_4
XFILLER_38_674 VDD VSS sg13cmos5l_decap_8
X_4006_ _4033_/A _5335_/B _4156_/A1 _4005_/Y VDD VSS sg13cmos5l_a21o_1
XFILLER_53_633 VDD VSS sg13cmos5l_fill_1
XFILLER_80_430 VDD VSS sg13cmos5l_fill_1
XFILLER_41_817 VDD VSS sg13cmos5l_decap_8
X_5957_ _5957_/Y _5917_/B _5957_/B VDD VSS sg13cmos5l_nand2b_1
XFILLER_80_474 VDD VSS sg13cmos5l_decap_4
XFILLER_52_198 VDD VSS sg13cmos5l_fill_1
X_4908_ _4914_/A _4967_/A _4968_/A VDD VSS sg13cmos5l_xnor2_1
X_7627_ _7629_/A _7627_/A _7627_/B VDD VSS sg13cmos5l_nor2_1
X_5888_ _5890_/A _5888_/A1 _5889_/B _5889_/C VDD VSS sg13cmos5l_a21oi_1
X_4839_ _4840_/B _4839_/A _4839_/B VDD VSS sg13cmos5l_nand2_1
X_7558_ _7559_/B _7558_/A _7558_/B VDD VSS sg13cmos5l_nor2_1
X_7489_ _7602_/A _7605_/C _7489_/B VDD VSS sg13cmos5l_xnor2_1
X_6509_ _6519_/A _6518_/B _6518_/C VDD VSS sg13cmos5l_nor2_1
XFILLER_49_906 VDD VSS sg13cmos5l_decap_8
XFILLER_49_917 VDD VSS sg13cmos5l_fill_1
XFILLER_88_596 VDD VSS sg13cmos5l_fill_1
XFILLER_43_132 VDD VSS sg13cmos5l_fill_1
XFILLER_43_143 VDD VSS sg13cmos5l_fill_1
XFILLER_71_430 VDD VSS sg13cmos5l_decap_8
XFILLER_43_165 VDD VSS sg13cmos5l_fill_1
XFILLER_44_699 VDD VSS sg13cmos5l_decap_4
XFILLER_40_872 VDD VSS sg13cmos5l_decap_8
XFILLER_61_51 VDD VSS sg13cmos5l_fill_2
XANTENNA_6 input823/X VDD VSS sg13cmos5l_antennanp
XFILLER_66_202 VDD VSS sg13cmos5l_fill_2
XFILLER_13_4 VDD VSS sg13cmos5l_fill_2
XFILLER_55_909 VDD VSS sg13cmos5l_decap_8
XFILLER_66_257 VDD VSS sg13cmos5l_decap_4
XFILLER_66_268 VDD VSS sg13cmos5l_fill_1
XFILLER_82_706 VDD VSS sg13cmos5l_decap_8
X_6860_ _6862_/A _6860_/A _6860_/B VDD VSS sg13cmos5l_nand2_1
X_6791_ _6970_/A _6791_/A _6791_/B VDD VSS sg13cmos5l_xor2_1
X_5811_ _5811_/Y _5811_/A _5811_/B VDD VSS sg13cmos5l_nor2_1
X_5742_ _5742_/Y _5742_/A _5742_/B VDD VSS sg13cmos5l_nor2_1
X_5673_ _5675_/A _5674_/A _5674_/B _5674_/C VDD VSS sg13cmos5l_a21oi_1
X_7412_ _7413_/A _7407_/B _7570_/A _7438_/A VDD VSS sg13cmos5l_o21ai_1
X_4624_ _4672_/A _4580_/B _4580_/A _4623_/X VDD VSS sg13cmos5l_a21oi_1
X_4555_ _4615_/B _4504_/B _4505_/A _4502_/Y VDD VSS sg13cmos5l_a21oi_1
X_7274_ _7274_/Y _7274_/A _7484_/B VDD VSS sg13cmos5l_nor2_1
X_4486_ _4542_/A _4486_/A _4486_/B VDD VSS sg13cmos5l_nand2_1
X_6225_ _6225_/Y _6227_/A _6225_/B VDD VSS sg13cmos5l_nand2_1
X_6156_ _6156_/X _6134_/B _6134_/A _6155_/X VDD VSS sg13cmos5l_a21o_1
XFILLER_58_736 VDD VSS sg13cmos5l_fill_2
X_5107_ _7683_/D _5107_/A _5107_/B VDD VSS sg13cmos5l_xnor2_1
X_6087_ _6088_/B _6123_/B _6107_/B VDD VSS sg13cmos5l_xnor2_1
XFILLER_85_555 VDD VSS sg13cmos5l_decap_8
XFILLER_38_460 VDD VSS sg13cmos5l_decap_8
XFILLER_66_791 VDD VSS sg13cmos5l_fill_1
X_5038_ _5105_/A _4976_/B _4977_/A _5037_/Y VDD VSS sg13cmos5l_o21ai_1
XFILLER_15_11 VDD VSS sg13cmos5l_decap_8
XFILLER_41_614 VDD VSS sg13cmos5l_decap_8
X_6989_ _7638_/B _6989_/A _6989_/B VDD VSS sg13cmos5l_nand2_2
XFILLER_40_168 VDD VSS sg13cmos5l_decap_4
XFILLER_88_360 VDD VSS sg13cmos5l_decap_4
XFILLER_37_909 VDD VSS sg13cmos5l_fill_2
XFILLER_64_706 VDD VSS sg13cmos5l_fill_2
XFILLER_56_51 VDD VSS sg13cmos5l_fill_2
XFILLER_64_739 VDD VSS sg13cmos5l_fill_1
XFILLER_72_761 VDD VSS sg13cmos5l_fill_1
XFILLER_44_496 VDD VSS sg13cmos5l_decap_4
X_4340_ _4356_/A _4340_/A _4340_/B VDD VSS sg13cmos5l_xor2_1
X_4271_ _4272_/B _4434_/B1 _3999_/A wire980/X _4271_/B2 VDD VSS sg13cmos5l_a22oi_1
X_6010_ _6010_/X _6010_/A _6010_/B VDD VSS sg13cmos5l_and2_1
XFILLER_55_706 VDD VSS sg13cmos5l_fill_1
XFILLER_67_566 VDD VSS sg13cmos5l_decap_4
XFILLER_54_205 VDD VSS sg13cmos5l_decap_4
XFILLER_70_709 VDD VSS sg13cmos5l_decap_8
X_6912_ _7052_/A _6918_/B _6759_/A _6911_/Y VDD VSS sg13cmos5l_o21ai_1
Xplace750 place750/X place754/A VDD VSS sg13cmos5l_buf_1
X_6843_ _6843_/X _6843_/A _6945_/B VDD VSS sg13cmos5l_and2_1
XFILLER_62_282 VDD VSS sg13cmos5l_fill_2
X_6774_ _6775_/B _7001_/A _7002_/B _6773_/Y VDD VSS sg13cmos5l_a21oi_1
X_3986_ _7662_/D _3986_/A _3988_/A VDD VSS sg13cmos5l_xnor2_1
X_5725_ _5726_/B _5776_/A _5776_/B VDD VSS sg13cmos5l_xor2_1
X_5656_ _5657_/B _5656_/A _5656_/B VDD VSS sg13cmos5l_nor2_1
X_4607_ _4607_/Y _4607_/A VDD VSS sg13cmos5l_inv_1
X_5587_ _5589_/A _5709_/B _5588_/A VDD VSS sg13cmos5l_nor2_1
Xrebuffer2031 _6533_/C _6250_/A VDD VSS sg13cmos5l_buf_1
X_7326_ _7326_/Y _7326_/A _7326_/B VDD VSS sg13cmos5l_nand2_1
X_4538_ _4553_/B _4557_/A _4538_/B VDD VSS sg13cmos5l_xnor2_1
Xrebuffer2042 _6291_/A _7711_/Q VDD VSS sg13cmos5l_buf_1
Xrebuffer2053 _6814_/A _6383_/A VDD VSS sg13cmos5l_buf_1
X_7257_ _7543_/B _7257_/A _7307_/B VDD VSS sg13cmos5l_nand2_1
X_4469_ _4469_/Y _4468_/B _4469_/B VDD VSS sg13cmos5l_nand2b_1
XFILLER_77_28 VDD VSS sg13cmos5l_fill_2
Xrebuffer1352 rebuffer1352/X rebuffer1353/X VDD VSS sg13cmos5l_buf_1
Xrebuffer1341 rebuffer1341/X rebuffer1342/X VDD VSS sg13cmos5l_buf_1
Xrebuffer1330 _6577_/B _6265_/B VDD VSS sg13cmos5l_buf_1
X_6208_ _6208_/Y _6210_/A _6208_/B VDD VSS sg13cmos5l_nor2_1
XFILLER_58_533 VDD VSS sg13cmos5l_decap_8
Xrebuffer1396 _7516_/A1 _7355_/A VDD VSS sg13cmos5l_buf_1
Xrebuffer1385 rebuffer1385/X rebuffer1386/X VDD VSS sg13cmos5l_buf_1
Xrebuffer1374 rebuffer1374/X _6987_/B VDD VSS sg13cmos5l_buf_1
Xrebuffer1363 rebuffer1363/X rebuffer1364/X VDD VSS sg13cmos5l_buf_1
X_7188_ _7188_/Y _7187_/A _7081_/A _7187_/Y VDD VSS sg13cmos5l_a21oi_1
X_6139_ _6139_/Y _6139_/A _6139_/B VDD VSS sg13cmos5l_nand2_1
XFILLER_86_864 VDD VSS sg13cmos5l_decap_8
XFILLER_85_352 VDD VSS sg13cmos5l_fill_1
XFILLER_45_216 VDD VSS sg13cmos5l_decap_8
XFILLER_45_227 VDD VSS sg13cmos5l_fill_1
XFILLER_73_536 VDD VSS sg13cmos5l_fill_1
XFILLER_73_547 VDD VSS sg13cmos5l_decap_8
XFILLER_73_558 VDD VSS sg13cmos5l_fill_1
XFILLER_73_569 VDD VSS sg13cmos5l_fill_2
XFILLER_53_271 VDD VSS sg13cmos5l_fill_2
XFILLER_54_794 VDD VSS sg13cmos5l_decap_8
XFILLER_41_488 VDD VSS sg13cmos5l_decap_8
XFILLER_42_53 VDD VSS sg13cmos5l_fill_2
XFILLER_77_886 VDD VSS sg13cmos5l_decap_8
XFILLER_64_569 VDD VSS sg13cmos5l_fill_2
XFILLER_60_731 VDD VSS sg13cmos5l_fill_1
XFILLER_60_775 VDD VSS sg13cmos5l_decap_4
X_5510_ _5511_/B _5561_/A _5561_/B VDD VSS sg13cmos5l_xor2_1
X_6490_ _6492_/A _6490_/A _6630_/B VDD VSS sg13cmos5l_nor2_1
X_5441_ _5452_/A _5630_/A _5441_/B VDD VSS sg13cmos5l_xnor2_1
X_5372_ _5373_/B _5432_/A _5372_/B VDD VSS sg13cmos5l_xnor2_1
X_7111_ _7290_/A _7111_/A _7274_/A _7484_/B VDD VSS sg13cmos5l_nor3_1
Xfanout118 _5870_/A _5897_/B VDD VSS sg13cmos5l_buf_1
X_7042_ _7043_/A _7715_/Q _7042_/B VDD VSS sg13cmos5l_xnor2_1
XFILLER_68_831 VDD VSS sg13cmos5l_decap_8
X_4254_ _4296_/B _4252_/Y _4229_/A _4253_/Y VDD VSS sg13cmos5l_o21ai_1
X_4185_ _4186_/A _4185_/A _4185_/B VDD VSS sg13cmos5l_xnor2_1
XFILLER_67_374 VDD VSS sg13cmos5l_fill_1
XFILLER_83_845 VDD VSS sg13cmos5l_decap_8
Xplace580 _6407_/B _6945_/B VDD VSS sg13cmos5l_buf_2
Xplace591 _7298_/A1 _7195_/B VDD VSS sg13cmos5l_buf_1
X_6826_ _6826_/Y _6826_/A _6826_/B VDD VSS sg13cmos5l_xnor2_1
XFILLER_51_797 VDD VSS sg13cmos5l_decap_8
X_6757_ _6759_/A _6757_/A _6757_/B VDD VSS sg13cmos5l_xnor2_1
X_5708_ _5710_/A _4176_/A _5705_/A _5707_/Y VDD VSS sg13cmos5l_o21ai_1
X_3969_ _3995_/A quant_cfg[3] VDD VSS sg13cmos5l_buf_1
X_6688_ _6690_/A _6688_/A _6688_/B VDD VSS sg13cmos5l_nand2_1
X_5639_ _5649_/A _5639_/A _5639_/B VDD VSS sg13cmos5l_xor2_1
X_7309_ _7310_/B _7304_/B _7305_/Y _7308_/Y VDD VSS sg13cmos5l_a21oi_1
XFILLER_78_639 VDD VSS sg13cmos5l_fill_2
XFILLER_77_127 VDD VSS sg13cmos5l_decap_4
XFILLER_58_330 VDD VSS sg13cmos5l_fill_2
XFILLER_59_842 VDD VSS sg13cmos5l_decap_8
XFILLER_74_801 VDD VSS sg13cmos5l_decap_8
XFILLER_86_661 VDD VSS sg13cmos5l_decap_8
XFILLER_37_97 VDD VSS sg13cmos5l_fill_1
XFILLER_74_878 VDD VSS sg13cmos5l_decap_8
XFILLER_61_539 VDD VSS sg13cmos5l_fill_1
XFILLER_41_296 VDD VSS sg13cmos5l_fill_1
XFILLER_69_606 VDD VSS sg13cmos5l_fill_2
XFILLER_68_105 VDD VSS sg13cmos5l_decap_4
XFILLER_37_503 VDD VSS sg13cmos5l_decap_8
XFILLER_49_363 VDD VSS sg13cmos5l_decap_8
XFILLER_37_558 VDD VSS sg13cmos5l_fill_1
XFILLER_65_878 VDD VSS sg13cmos5l_decap_8
X_5990_ _5991_/B _5990_/A _5946_/A VDD VSS sg13cmos5l_nor2b_1
XFILLER_80_815 VDD VSS sg13cmos5l_decap_8
X_4941_ _4942_/B _4701_/A _5009_/A2 _4646_/A _5140_/B2 VDD VSS sg13cmos5l_a22oi_1
X_7660_ _7660_/Q clkload0/A _7660_/D place748/X VDD VSS sg13cmos5l_dfrbpq_1
XFILLER_60_572 VDD VSS sg13cmos5l_fill_1
XFILLER_60_583 VDD VSS sg13cmos5l_decap_8
X_6611_ _6613_/A _6611_/A _6611_/B _6611_/C VDD VSS sg13cmos5l_nand3_1
X_7591_ _7592_/C _7591_/A _7591_/B VDD VSS sg13cmos5l_xor2_1
XFILLER_71_0 VDD VSS sg13cmos5l_fill_1
X_6542_ _6549_/A _6542_/A _6542_/B VDD VSS sg13cmos5l_nor2_1
X_6473_ _6841_/B _6473_/A _6473_/B VDD VSS sg13cmos5l_nand2_2
X_5424_ _5426_/A _5411_/A _5424_/B VDD VSS sg13cmos5l_nand2b_1
X_5355_ _5418_/B _5355_/A _5417_/A VDD VSS sg13cmos5l_xor2_1
XFILLER_59_116 VDD VSS sg13cmos5l_decap_8
X_5286_ _5288_/A _5216_/B _5286_/B VDD VSS sg13cmos5l_nand2b_1
X_4306_ _4360_/B _4268_/B _4268_/A _4305_/X VDD VSS sg13cmos5l_a21oi_1
Xwire1008 _4820_/B1 wire1008/A VDD VSS sg13cmos5l_buf_2
Xwire1019 _3999_/B wire1020/X VDD VSS sg13cmos5l_buf_2
X_7025_ _7025_/Y _7144_/B _7237_/B _7024_/X VDD VSS sg13cmos5l_o21ai_1
X_4237_ _4243_/A _4237_/A _4237_/B VDD VSS sg13cmos5l_xnor2_1
XFILLER_87_447 VDD VSS sg13cmos5l_decap_8
XFILLER_55_300 VDD VSS sg13cmos5l_decap_8
XFILLER_68_683 VDD VSS sg13cmos5l_decap_8
XFILLER_55_311 VDD VSS sg13cmos5l_fill_1
XFILLER_67_171 VDD VSS sg13cmos5l_decap_8
X_4168_ _4178_/A _4168_/A _4168_/B VDD VSS sg13cmos5l_xnor2_1
XFILLER_83_642 VDD VSS sg13cmos5l_decap_8
XFILLER_56_889 VDD VSS sg13cmos5l_decap_8
XFILLER_70_303 VDD VSS sg13cmos5l_decap_8
X_4099_ _4106_/A _4099_/A _4108_/A VDD VSS sg13cmos5l_xnor2_1
XFILLER_70_325 VDD VSS sg13cmos5l_fill_2
XFILLER_71_837 VDD VSS sg13cmos5l_decap_8
Xbank_A_sram.gen_ihp_256x32.u_sram_256x32_1182 bank_A_sram.gen_ihp_256x32.u_sram_256x32/A_BM[7]
+ VDD VSS sg13cmos5l_tiehi
Xbank_A_sram.gen_ihp_256x32.u_sram_256x32_1193 bank_A_sram.gen_ihp_256x32.u_sram_256x32/A_BM[18]
+ VDD VSS sg13cmos5l_tiehi
XFILLER_48_30 VDD VSS sg13cmos5l_decap_8
XFILLER_48_52 VDD VSS sg13cmos5l_fill_1
XFILLER_47_823 VDD VSS sg13cmos5l_decap_8
XFILLER_58_160 VDD VSS sg13cmos5l_fill_2
XFILLER_46_344 VDD VSS sg13cmos5l_fill_2
XFILLER_73_152 VDD VSS sg13cmos5l_fill_2
XFILLER_46_388 VDD VSS sg13cmos5l_fill_2
XFILLER_61_303 VDD VSS sg13cmos5l_decap_4
XFILLER_62_859 VDD VSS sg13cmos5l_decap_8
XFILLER_64_51 VDD VSS sg13cmos5l_decap_8
XFILLER_64_62 VDD VSS sg13cmos5l_decap_8
XFILLER_64_73 VDD VSS sg13cmos5l_fill_1
XFILLER_74_686 VDD VSS sg13cmos5l_decap_8
XFILLER_42_594 VDD VSS sg13cmos5l_decap_4
XFILLER_80_50 VDD VSS sg13cmos5l_fill_2
XFILLER_43_4 VDD VSS sg13cmos5l_fill_2
Xrebuffer1918 rebuffer1918/X rebuffer1919/X VDD VSS sg13cmos5l_buf_1
Xrebuffer1907 rebuffer1907/X rebuffer1908/X VDD VSS sg13cmos5l_buf_1
Xrebuffer1929 rebuffer1929/X rebuffer1930/X VDD VSS sg13cmos5l_buf_1
X_5140_ _5141_/B _4888_/A _5514_/A2 _4825_/A _5140_/B2 VDD VSS sg13cmos5l_a22oi_1
X_5071_ _5127_/A _5020_/B _5020_/A _5070_/Y VDD VSS sg13cmos5l_a21oi_1
X_4022_ _4025_/A _3955_/A _4023_/A _3960_/Y VDD VSS sg13cmos5l_a21oi_1
XFILLER_84_428 VDD VSS sg13cmos5l_fill_1
XFILLER_84_406 VDD VSS sg13cmos5l_decap_8
XFILLER_38_856 VDD VSS sg13cmos5l_decap_8
XFILLER_65_620 VDD VSS sg13cmos5l_fill_2
XFILLER_65_664 VDD VSS sg13cmos5l_decap_8
X_5973_ _5973_/Y _5973_/A _5954_/A VDD VSS sg13cmos5l_nor2b_1
XFILLER_80_612 VDD VSS sg13cmos5l_fill_1
X_7712_ _7712_/Q _7712_/CLK _7712_/D place749/X VDD VSS sg13cmos5l_dfrbpq_2
X_4924_ _4924_/X _4924_/A _4924_/B VDD VSS sg13cmos5l_and2_1
XFILLER_80_656 VDD VSS sg13cmos5l_decap_8
X_7643_ _7644_/B _7643_/A _7643_/B VDD VSS sg13cmos5l_xnor2_1
X_4855_ _4855_/Y _4855_/A _4805_/A VDD VSS sg13cmos5l_nor2b_1
X_7574_ _7576_/A _7574_/A _7574_/B VDD VSS sg13cmos5l_nand2_1
X_4786_ _4847_/B _4786_/A _4846_/A VDD VSS sg13cmos5l_xnor2_1
X_6525_ _6534_/B _6377_/B _6541_/A VDD VSS sg13cmos5l_nand2b_1
X_6456_ _6456_/Y _6457_/A _6457_/C _6457_/B VDD VSS sg13cmos5l_a21oi_1
X_6387_ _6389_/B _6621_/A _6671_/B VDD VSS sg13cmos5l_nand2_1
X_5407_ _5409_/A _5345_/B _5407_/B VDD VSS sg13cmos5l_nand2b_1
X_5338_ _5339_/B _5205_/A _5585_/A2 _5145_/A _5585_/B2 VDD VSS sg13cmos5l_a22oi_1
X_7008_ _7326_/B _7235_/A _7294_/B VDD VSS sg13cmos5l_nand2_1
XFILLER_88_789 VDD VSS sg13cmos5l_decap_4
XFILLER_75_417 VDD VSS sg13cmos5l_decap_8
XFILLER_56_620 VDD VSS sg13cmos5l_decap_8
XFILLER_55_152 VDD VSS sg13cmos5l_decap_8
XFILLER_44_848 VDD VSS sg13cmos5l_decap_8
XFILLER_51_380 VDD VSS sg13cmos5l_fill_1
XFILLER_50_31 VDD VSS sg13cmos5l_decap_8
XFILLER_59_62 VDD VSS sg13cmos5l_fill_1
XFILLER_59_73 VDD VSS sg13cmos5l_fill_1
XFILLER_59_95 VDD VSS sg13cmos5l_decap_8
XFILLER_59_491 VDD VSS sg13cmos5l_fill_1
Xclkbuf_4_3_0_clk_i_regs clkload1/A clkbuf_0_clk_i_regs/X VDD VSS sg13cmos5l_buf_8
XFILLER_47_642 VDD VSS sg13cmos5l_fill_2
XFILLER_47_664 VDD VSS sg13cmos5l_decap_4
XFILLER_46_185 VDD VSS sg13cmos5l_decap_8
XFILLER_62_634 VDD VSS sg13cmos5l_decap_8
XFILLER_61_177 VDD VSS sg13cmos5l_fill_2
XFILLER_43_892 VDD VSS sg13cmos5l_decap_8
X_6310_ _6319_/A _6310_/A _6310_/B VDD VSS sg13cmos5l_nand2_2
X_4571_ _4602_/A _4571_/A _4571_/B VDD VSS sg13cmos5l_xor2_1
X_7290_ _7290_/Y _7290_/A _7290_/B _7290_/C VDD VSS sg13cmos5l_nor3_1
X_6241_ _6277_/A _6241_/A _6291_/A VDD VSS sg13cmos5l_nand2_2
X_6172_ _7705_/D _6172_/A _6172_/B VDD VSS sg13cmos5l_xor2_1
XFILLER_34_0 VDD VSS sg13cmos5l_fill_2
XFILLER_69_222 VDD VSS sg13cmos5l_fill_2
X_5123_ _5123_/X _5123_/A _5123_/B VDD VSS sg13cmos5l_and2_1
XFILLER_57_406 VDD VSS sg13cmos5l_fill_2
X_5054_ _5054_/X _5054_/A _5054_/B VDD VSS sg13cmos5l_and2_1
XFILLER_85_737 VDD VSS sg13cmos5l_decap_8
XFILLER_37_130 VDD VSS sg13cmos5l_fill_2
X_4005_ _4005_/Y _4005_/A _4005_/B VDD VSS sg13cmos5l_nor2_1
XFILLER_53_612 VDD VSS sg13cmos5l_fill_1
XFILLER_81_910 VDD VSS sg13cmos5l_decap_8
XFILLER_111_15 VDD VSS sg13cmos5l_decap_4
XFILLER_37_196 VDD VSS sg13cmos5l_decap_4
XFILLER_53_656 VDD VSS sg13cmos5l_fill_2
XFILLER_71_19 VDD VSS sg13cmos5l_decap_8
X_5956_ _5999_/B _5956_/A _5975_/A VDD VSS sg13cmos5l_xnor2_1
X_5887_ _5889_/C _5933_/B _5933_/A VDD VSS sg13cmos5l_xor2_1
X_4907_ _4968_/A _4969_/B _4969_/A VDD VSS sg13cmos5l_xor2_1
X_7626_ _7627_/A _7626_/A _7626_/B _7626_/C VDD VSS sg13cmos5l_nand3_1
X_4838_ _4839_/B _4776_/A _4838_/B VDD VSS sg13cmos5l_nand2b_1
X_7557_ _7558_/A _7557_/A _7557_/B VDD VSS sg13cmos5l_nor2_1
X_4769_ _4818_/A _4947_/B _4701_/A _4768_/Y VDD VSS sg13cmos5l_a21o_1
X_7488_ _7489_/B _7488_/A _7488_/B VDD VSS sg13cmos5l_nand2_1
X_6508_ _6518_/C _6508_/A _6508_/B VDD VSS sg13cmos5l_nand2_1
X_6439_ _6548_/D _6541_/A VDD VSS sg13cmos5l_inv_1
XFILLER_88_531 VDD VSS sg13cmos5l_fill_1
XFILLER_63_409 VDD VSS sg13cmos5l_decap_8
XFILLER_44_623 VDD VSS sg13cmos5l_fill_1
XFILLER_44_667 VDD VSS sg13cmos5l_fill_1
XFILLER_56_494 VDD VSS sg13cmos5l_decap_8
XFILLER_83_291 VDD VSS sg13cmos5l_fill_1
XFILLER_71_486 VDD VSS sg13cmos5l_fill_2
XFILLER_40_851 VDD VSS sg13cmos5l_decap_8
XANTENNA_7 input824/X VDD VSS sg13cmos5l_antennanp
XFILLER_67_737 VDD VSS sg13cmos5l_fill_2
XFILLER_86_71 VDD VSS sg13cmos5l_fill_1
XFILLER_63_910 VDD VSS sg13cmos5l_decap_8
X_6790_ _6968_/A _6790_/A _6790_/B VDD VSS sg13cmos5l_xnor2_1
X_5810_ _5810_/Y _5810_/A _5810_/B VDD VSS sg13cmos5l_nand2_1
X_5741_ _5741_/Y _5742_/B _5742_/A VDD VSS sg13cmos5l_nand2_1
X_7411_ _7414_/B _7411_/A VDD VSS sg13cmos5l_inv_1
X_5672_ _5674_/C _5733_/B _5733_/A VDD VSS sg13cmos5l_xor2_1
X_4623_ _4623_/X _4623_/A _4623_/B VDD VSS sg13cmos5l_and2_1
X_7342_ _7348_/A _7342_/A _7342_/B _7524_/A VDD VSS sg13cmos5l_nand3_1
X_4554_ _4614_/A _4542_/A _4552_/Y _4553_/Y VDD VSS sg13cmos5l_o21ai_1
X_6224_ _6224_/Y _6210_/A _6201_/Y _6223_/Y VDD VSS sg13cmos5l_o21ai_1
X_6155_ _6155_/X _6155_/A _6155_/B VDD VSS sg13cmos5l_and2_1
X_6086_ _6107_/B _6117_/B _6117_/A VDD VSS sg13cmos5l_xnor2_1
X_5106_ _5107_/B _5104_/Y _5106_/B VDD VSS sg13cmos5l_nand2b_1
X_5037_ _5037_/Y _4972_/A _4974_/X _4972_/B VDD VSS sg13cmos5l_o21ai_1
XFILLER_72_228 VDD VSS sg13cmos5l_decap_8
XFILLER_53_420 VDD VSS sg13cmos5l_decap_8
XFILLER_53_442 VDD VSS sg13cmos5l_fill_1
XFILLER_72_239 VDD VSS sg13cmos5l_fill_2
XFILLER_81_784 VDD VSS sg13cmos5l_decap_8
X_6988_ _6989_/B _6988_/A _7714_/Q _6988_/C VDD VSS sg13cmos5l_nand3_1
XFILLER_40_147 VDD VSS sg13cmos5l_decap_8
X_5939_ _5939_/Y _5939_/A _5915_/A VDD VSS sg13cmos5l_nor2b_1
X_7609_ _7609_/Y _7609_/A _7728_/D VDD VSS sg13cmos5l_nand2_2
XFILLER_49_748 VDD VSS sg13cmos5l_decap_8
XFILLER_88_383 VDD VSS sg13cmos5l_decap_8
XFILLER_57_770 VDD VSS sg13cmos5l_decap_8
XFILLER_63_217 VDD VSS sg13cmos5l_decap_8
XFILLER_63_239 VDD VSS sg13cmos5l_fill_1
XFILLER_44_475 VDD VSS sg13cmos5l_fill_1
XFILLER_60_902 VDD VSS sg13cmos5l_decap_8
XFILLER_40_670 VDD VSS sg13cmos5l_decap_4
X_4270_ _4283_/A _4225_/B _4225_/A _4269_/Y VDD VSS sg13cmos5l_a21oi_1
XFILLER_54_217 VDD VSS sg13cmos5l_decap_8
XFILLER_67_578 VDD VSS sg13cmos5l_fill_2
XFILLER_48_792 VDD VSS sg13cmos5l_fill_1
X_6911_ _6911_/Y _6764_/Y _6918_/B VDD VSS sg13cmos5l_nand2b_1
XFILLER_82_559 VDD VSS sg13cmos5l_decap_4
XFILLER_51_902 VDD VSS sg13cmos5l_decap_8
Xplace740 _4172_/A _3960_/A VDD VSS sg13cmos5l_buf_1
X_6842_ _6843_/A _6842_/A _6842_/B VDD VSS sg13cmos5l_xor2_1
XFILLER_50_412 VDD VSS sg13cmos5l_decap_8
XFILLER_50_423 VDD VSS sg13cmos5l_fill_2
XFILLER_50_434 VDD VSS sg13cmos5l_decap_4
XFILLER_63_795 VDD VSS sg13cmos5l_fill_2
Xplace751 place751/X place754/X VDD VSS sg13cmos5l_buf_1
X_6773_ _6773_/Y _7002_/B _7028_/A VDD VSS sg13cmos5l_nor2_1
X_3985_ _3988_/A _3987_/A _3987_/B VDD VSS sg13cmos5l_xnor2_1
X_5724_ _5776_/B _5722_/Y _5652_/A _5723_/Y VDD VSS sg13cmos5l_a21oi_1
X_5655_ _5656_/B _5655_/A _5594_/A VDD VSS sg13cmos5l_nor2b_1
X_4606_ _4726_/B _4606_/A _4606_/B _4607_/A VDD VSS sg13cmos5l_nor3_1
X_7325_ _7332_/A _7325_/A _7550_/B _7551_/B VDD VSS sg13cmos5l_nand3_1
X_5586_ _5588_/A _5586_/A _5586_/B VDD VSS sg13cmos5l_xnor2_1
Xrebuffer2010 _4297_/A _4288_/A VDD VSS sg13cmos5l_buf_1
X_4537_ _4538_/B _4537_/A _4558_/B VDD VSS sg13cmos5l_xor2_1
Xrebuffer2032 _6320_/B _6317_/Y VDD VSS sg13cmos5l_buf_1
Xrebuffer2043 _6771_/B _6583_/A VDD VSS sg13cmos5l_buf_1
Xrebuffer2054 _6811_/A _6350_/B VDD VSS sg13cmos5l_buf_1
Xrebuffer1320 rebuffer1320/X rebuffer1321/X VDD VSS sg13cmos5l_buf_1
X_7256_ _7542_/A _7259_/A _7307_/B VDD VSS sg13cmos5l_nand2b_1
X_4468_ _4545_/A _4473_/B _4468_/B VDD VSS sg13cmos5l_nand2_1
Xrebuffer1353 rebuffer1353/X rebuffer1354/X VDD VSS sg13cmos5l_buf_1
Xrebuffer1342 rebuffer1342/X _7361_/A VDD VSS sg13cmos5l_buf_1
Xrebuffer1331 rebuffer1331/X _6677_/A VDD VSS sg13cmos5l_buf_1
X_7187_ _7187_/Y _7187_/A _7187_/B VDD VSS sg13cmos5l_nor2_1
X_6207_ _6207_/Y _6207_/A VDD VSS sg13cmos5l_inv_1
Xrebuffer1386 rebuffer1386/X rebuffer1390/X VDD VSS sg13cmos5l_buf_1
Xrebuffer1375 _7583_/B _7439_/A VDD VSS sg13cmos5l_buf_1
Xrebuffer1364 rebuffer1364/X rebuffer1365/X VDD VSS sg13cmos5l_buf_1
X_6138_ _6163_/A _6138_/A _6138_/B VDD VSS sg13cmos5l_xnor2_1
X_4399_ _4399_/Y _4399_/A VDD VSS sg13cmos5l_inv_1
XFILLER_86_843 VDD VSS sg13cmos5l_decap_8
Xrebuffer1397 _7563_/A1 _7368_/A VDD VSS sg13cmos5l_buf_1
XFILLER_58_589 VDD VSS sg13cmos5l_fill_2
X_6069_ _6097_/A _6035_/B _6067_/Y _6068_/Y VDD VSS sg13cmos5l_a21oi_1
XFILLER_39_792 VDD VSS sg13cmos5l_decap_8
XFILLER_41_434 VDD VSS sg13cmos5l_decap_8
XFILLER_53_294 VDD VSS sg13cmos5l_decap_4
XFILLER_42_87 VDD VSS sg13cmos5l_fill_1
XFILLER_49_523 VDD VSS sg13cmos5l_fill_1
XFILLER_88_191 VDD VSS sg13cmos5l_fill_1
XFILLER_77_865 VDD VSS sg13cmos5l_decap_8
XFILLER_37_718 VDD VSS sg13cmos5l_decap_4
XFILLER_64_515 VDD VSS sg13cmos5l_fill_1
XFILLER_45_773 VDD VSS sg13cmos5l_decap_4
XFILLER_44_283 VDD VSS sg13cmos5l_fill_1
XFILLER_60_754 VDD VSS sg13cmos5l_decap_8
XFILLER_60_798 VDD VSS sg13cmos5l_fill_2
X_5440_ _5441_/B _5745_/B1 _6021_/A2 _5684_/B1 _6021_/B2 VDD VSS sg13cmos5l_a22oi_1
X_5371_ _5372_/B _5557_/B1 _5623_/A2 _5493_/B1 _5687_/B2 VDD VSS sg13cmos5l_a22oi_1
X_7110_ _7110_/Y _7107_/Y _7109_/A _7109_/Y VDD VSS sg13cmos5l_a21oi_1
X_4322_ _4333_/A _4322_/A _4322_/B VDD VSS sg13cmos5l_xnor2_1
Xfanout119 _5547_/A _5480_/A VDD VSS sg13cmos5l_buf_1
X_7041_ _7042_/B _7096_/A _7096_/C VDD VSS sg13cmos5l_nand2_1
X_4253_ _4253_/Y _4228_/A _4253_/B VDD VSS sg13cmos5l_nand2b_1
XFILLER_68_810 VDD VSS sg13cmos5l_decap_8
X_4184_ _4185_/A _4184_/A _4184_/B VDD VSS sg13cmos5l_xor2_1
XFILLER_67_353 VDD VSS sg13cmos5l_fill_2
XFILLER_68_887 VDD VSS sg13cmos5l_decap_8
XFILLER_83_824 VDD VSS sg13cmos5l_decap_8
XFILLER_82_301 VDD VSS sg13cmos5l_decap_8
XFILLER_82_334 VDD VSS sg13cmos5l_decap_4
XFILLER_51_721 VDD VSS sg13cmos5l_decap_4
XFILLER_63_581 VDD VSS sg13cmos5l_fill_1
Xplace570 _5585_/A2 _3948_/Y VDD VSS sg13cmos5l_buf_1
Xplace581 _6968_/B _6945_/B VDD VSS sg13cmos5l_buf_1
Xplace592 _7195_/B _7144_/B VDD VSS sg13cmos5l_buf_1
X_6825_ _6825_/Y _6822_/X _6957_/S _6824_/X VDD VSS sg13cmos5l_a21oi_1
X_6756_ _6915_/B _6756_/A _6756_/B VDD VSS sg13cmos5l_xnor2_1
X_3968_ _3986_/A _3968_/A _3970_/B VDD VSS sg13cmos5l_nor2_1
X_5707_ _5707_/Y _4176_/A _3948_/B _5706_/Y VDD VSS sg13cmos5l_o21ai_1
X_6687_ _6716_/B _6687_/A _6687_/B VDD VSS sg13cmos5l_nand2_2
X_5638_ _5639_/B _5690_/A _5690_/B VDD VSS sg13cmos5l_xor2_1
X_7308_ _7308_/Y _7308_/A _7555_/B VDD VSS sg13cmos5l_nand2_1
XFILLER_78_618 VDD VSS sg13cmos5l_fill_1
XFILLER_59_810 VDD VSS sg13cmos5l_decap_4
X_7239_ _7239_/Y _7195_/B _7038_/A _7238_/Y VDD VSS sg13cmos5l_o21ai_1
XFILLER_86_640 VDD VSS sg13cmos5l_decap_8
XFILLER_37_32 VDD VSS sg13cmos5l_fill_1
XFILLER_59_898 VDD VSS sg13cmos5l_decap_8
XFILLER_37_43 VDD VSS sg13cmos5l_fill_2
XFILLER_74_857 VDD VSS sg13cmos5l_decap_8
Xclkbuf_4_8_0_clk_i_regs _7704_/CLK clkbuf_0_clk_i_regs/X VDD VSS sg13cmos5l_buf_8
XFILLER_73_367 VDD VSS sg13cmos5l_fill_1
XFILLER_53_31 VDD VSS sg13cmos5l_decap_4
XFILLER_53_42 VDD VSS sg13cmos5l_fill_2
XFILLER_53_64 VDD VSS sg13cmos5l_fill_2
XFILLER_45_8 VDD VSS sg13cmos5l_fill_1
XFILLER_37_548 VDD VSS sg13cmos5l_fill_2
XFILLER_49_397 VDD VSS sg13cmos5l_fill_2
XFILLER_65_857 VDD VSS sg13cmos5l_decap_8
XFILLER_77_695 VDD VSS sg13cmos5l_decap_8
XFILLER_76_194 VDD VSS sg13cmos5l_decap_8
XFILLER_64_356 VDD VSS sg13cmos5l_decap_4
X_4940_ _4994_/A _4895_/B _4895_/A _4939_/Y VDD VSS sg13cmos5l_a21oi_1
X_4871_ _5192_/A _4871_/A VDD VSS sg13cmos5l_buf_1
XFILLER_60_551 VDD VSS sg13cmos5l_fill_2
X_7590_ _7591_/B _7590_/A _7590_/B VDD VSS sg13cmos5l_nand2_1
X_6610_ _6756_/B _6610_/A _6610_/B VDD VSS sg13cmos5l_nand2_2
X_6541_ _6549_/B _6541_/A _6541_/B VDD VSS sg13cmos5l_nand2_1
X_6472_ _6473_/B _6470_/B _7679_/Q VDD VSS sg13cmos5l_nand2b_1
X_5423_ _7688_/D _5485_/B _5423_/B VDD VSS sg13cmos5l_xor2_1
X_5354_ _5417_/A _5363_/B _5363_/A VDD VSS sg13cmos5l_xnor2_1
X_4305_ _4305_/X _4305_/A _4305_/B VDD VSS sg13cmos5l_and2_1
XFILLER_88_916 VDD VSS sg13cmos5l_fill_2
X_5285_ _5351_/B _5346_/A _5285_/B VDD VSS sg13cmos5l_xnor2_1
XFILLER_87_426 VDD VSS sg13cmos5l_decap_8
XFILLER_87_404 VDD VSS sg13cmos5l_fill_1
X_7024_ _7024_/X _7020_/Y _7023_/Y _6321_/B VDD VSS sg13cmos5l_a21o_1
X_4236_ _4237_/A _4236_/A _4236_/B VDD VSS sg13cmos5l_nor2_1
XFILLER_68_673 VDD VSS sg13cmos5l_fill_1
X_4167_ _4168_/B _4023_/A _4167_/A2 _4003_/A _4271_/B2 VDD VSS sg13cmos5l_a22oi_1
XFILLER_83_621 VDD VSS sg13cmos5l_decap_8
XFILLER_56_868 VDD VSS sg13cmos5l_decap_8
XFILLER_71_816 VDD VSS sg13cmos5l_decap_8
X_4098_ _4109_/A _4138_/B _4138_/A VDD VSS sg13cmos5l_xor2_1
XFILLER_55_389 VDD VSS sg13cmos5l_decap_8
XFILLER_64_890 VDD VSS sg13cmos5l_decap_8
XFILLER_83_698 VDD VSS sg13cmos5l_decap_8
XFILLER_82_186 VDD VSS sg13cmos5l_fill_1
XFILLER_82_175 VDD VSS sg13cmos5l_fill_1
XFILLER_70_337 VDD VSS sg13cmos5l_fill_1
XFILLER_23_12 VDD VSS sg13cmos5l_decap_8
X_6808_ _6808_/Y _6801_/Y _6808_/A2 _6807_/Y VDD VSS sg13cmos5l_a21oi_1
XFILLER_51_584 VDD VSS sg13cmos5l_decap_8
X_6739_ _6739_/Y _6739_/A VDD VSS sg13cmos5l_inv_1
XFILLER_3_4 VDD VSS sg13cmos5l_decap_8
Xbank_A_sram.gen_ihp_256x32.u_sram_256x32_1183 bank_A_sram.gen_ihp_256x32.u_sram_256x32/A_BM[8]
+ VDD VSS sg13cmos5l_tiehi
Xbank_A_sram.gen_ihp_256x32.u_sram_256x32_1194 bank_A_sram.gen_ihp_256x32.u_sram_256x32/A_BM[19]
+ VDD VSS sg13cmos5l_tiehi
XFILLER_78_404 VDD VSS sg13cmos5l_fill_1
XFILLER_48_75 VDD VSS sg13cmos5l_decap_8
XFILLER_48_97 VDD VSS sg13cmos5l_decap_8
XFILLER_46_367 VDD VSS sg13cmos5l_decap_4
XFILLER_47_879 VDD VSS sg13cmos5l_decap_8
XFILLER_73_131 VDD VSS sg13cmos5l_decap_4
XFILLER_74_665 VDD VSS sg13cmos5l_decap_8
Xbank_B_sram.gen_ihp_256x32.u_sram_256x32_1170 bank_B_sram.gen_ihp_256x32.u_sram_256x32_1170/L_LO
+ VDD VSS sg13cmos5l_tielo
XFILLER_62_838 VDD VSS sg13cmos5l_decap_8
XFILLER_61_359 VDD VSS sg13cmos5l_fill_2
XFILLER_42_562 VDD VSS sg13cmos5l_fill_2
XFILLER_70_882 VDD VSS sg13cmos5l_decap_8
XFILLER_80_84 VDD VSS sg13cmos5l_fill_2
XFILLER_80_95 VDD VSS sg13cmos5l_fill_2
Xrebuffer1919 rebuffer1919/X rebuffer1920/X VDD VSS sg13cmos5l_buf_1
Xrebuffer1908 rebuffer1908/X rebuffer1909/X VDD VSS sg13cmos5l_buf_1
X_5070_ _5070_/Y _5070_/A _5070_/B VDD VSS sg13cmos5l_nor2_1
XFILLER_38_835 VDD VSS sg13cmos5l_decap_8
XFILLER_49_183 VDD VSS sg13cmos5l_decap_8
XFILLER_37_389 VDD VSS sg13cmos5l_fill_1
X_5972_ _7698_/D _5972_/A _6016_/A VDD VSS sg13cmos5l_nor2b_1
XFILLER_46_890 VDD VSS sg13cmos5l_decap_8
X_7711_ _7711_/Q clkload5/A _7711_/D place749/X VDD VSS sg13cmos5l_dfrbpq_2
X_4923_ _4926_/A _4985_/S _4923_/B VDD VSS sg13cmos5l_xnor2_1
XFILLER_60_370 VDD VSS sg13cmos5l_fill_1
XFILLER_61_893 VDD VSS sg13cmos5l_decap_8
X_7642_ _7643_/B _7642_/A _7642_/B VDD VSS sg13cmos5l_nand2_1
X_4854_ _5048_/A _4854_/A VDD VSS sg13cmos5l_buf_1
X_7573_ _7580_/A _7573_/A _7573_/B _7621_/D VDD VSS sg13cmos5l_and3_1
X_4785_ _4846_/A _4785_/A _4785_/B VDD VSS sg13cmos5l_nand2_1
X_6524_ _6882_/B _6524_/A _6524_/B VDD VSS sg13cmos5l_nand2_2
XFILLER_109_15 VDD VSS sg13cmos5l_decap_4
X_6455_ _6457_/B _6291_/B _6483_/A VDD VSS sg13cmos5l_nand2b_1
X_6386_ _6671_/B _6979_/B _6533_/B _6407_/A _6533_/C VDD VSS sg13cmos5l_nor4_1
X_5406_ _5425_/B _5471_/B _5406_/B VDD VSS sg13cmos5l_xnor2_1
X_5337_ _5389_/A _5460_/B _5274_/A _5336_/Y VDD VSS sg13cmos5l_a21o_1
XFILLER_88_757 VDD VSS sg13cmos5l_fill_1
XFILLER_88_746 VDD VSS sg13cmos5l_fill_1
XFILLER_47_109 VDD VSS sg13cmos5l_fill_2
X_7007_ _7235_/A _7191_/B _7161_/A _7006_/Y VDD VSS sg13cmos5l_o21ai_1
X_4219_ _4220_/B _4447_/A _5335_/B _4219_/C VDD VSS sg13cmos5l_nor3_1
XFILLER_87_256 VDD VSS sg13cmos5l_decap_8
XFILLER_75_407 VDD VSS sg13cmos5l_decap_4
XFILLER_55_120 VDD VSS sg13cmos5l_fill_2
XFILLER_56_643 VDD VSS sg13cmos5l_fill_1
XFILLER_44_827 VDD VSS sg13cmos5l_decap_8
XFILLER_83_473 VDD VSS sg13cmos5l_decap_8
XFILLER_71_668 VDD VSS sg13cmos5l_decap_8
XFILLER_50_21 VDD VSS sg13cmos5l_fill_2
XFILLER_59_41 VDD VSS sg13cmos5l_decap_8
XFILLER_79_702 VDD VSS sg13cmos5l_decap_8
XFILLER_78_234 VDD VSS sg13cmos5l_fill_2
XFILLER_78_212 VDD VSS sg13cmos5l_fill_1
XFILLER_47_621 VDD VSS sg13cmos5l_decap_8
XFILLER_46_142 VDD VSS sg13cmos5l_fill_2
XFILLER_43_871 VDD VSS sg13cmos5l_decap_8
XFILLER_61_156 VDD VSS sg13cmos5l_decap_4
XFILLER_42_370 VDD VSS sg13cmos5l_fill_2
X_4570_ _4571_/B _4616_/B _4616_/A VDD VSS sg13cmos5l_xor2_1
XFILLER_41_2 VDD VSS sg13cmos5l_fill_1
XFILLER_69_201 VDD VSS sg13cmos5l_decap_8
X_6171_ _6172_/B _6156_/X _6157_/A _6170_/X VDD VSS sg13cmos5l_a21o_1
X_5122_ _5125_/A _5177_/S _5122_/B VDD VSS sg13cmos5l_xnor2_1
XFILLER_69_256 VDD VSS sg13cmos5l_decap_8
XFILLER_69_278 VDD VSS sg13cmos5l_fill_1
XFILLER_85_716 VDD VSS sg13cmos5l_decap_8
X_5053_ _5056_/A _5115_/S _5053_/B VDD VSS sg13cmos5l_xnor2_1
XFILLER_84_215 VDD VSS sg13cmos5l_fill_1
XFILLER_38_654 VDD VSS sg13cmos5l_decap_8
X_4004_ _4005_/B _4447_/A _5335_/B _4004_/C VDD VSS sg13cmos5l_nor3_1
XFILLER_37_164 VDD VSS sg13cmos5l_decap_4
XFILLER_52_101 VDD VSS sg13cmos5l_decap_8
XFILLER_53_646 VDD VSS sg13cmos5l_fill_2
XFILLER_80_443 VDD VSS sg13cmos5l_decap_4
XFILLER_52_156 VDD VSS sg13cmos5l_fill_1
XFILLER_53_668 VDD VSS sg13cmos5l_decap_8
XFILLER_53_679 VDD VSS sg13cmos5l_decap_4
X_5955_ _5975_/A _5955_/A _5955_/B VDD VSS sg13cmos5l_xnor2_1
XFILLER_40_318 VDD VSS sg13cmos5l_fill_2
XFILLER_52_178 VDD VSS sg13cmos5l_decap_8
X_5886_ _5933_/A _5927_/A _5885_/Y _5838_/B VDD VSS sg13cmos5l_o21ai_1
X_4906_ _4969_/A _4840_/B _4840_/A _4905_/Y VDD VSS sg13cmos5l_a21o_1
X_7625_ _7626_/C _7625_/A _7625_/B VDD VSS sg13cmos5l_nor2_1
X_4837_ _4839_/A _4777_/B _4837_/B VDD VSS sg13cmos5l_nand2b_1
X_7556_ _7560_/B _7556_/A _7556_/B VDD VSS sg13cmos5l_xor2_1
X_4768_ _4768_/Y _4768_/A _4768_/B VDD VSS sg13cmos5l_nor2_1
X_7487_ _7488_/B _7477_/B _7603_/A VDD VSS sg13cmos5l_nand2b_1
X_6507_ _6518_/B _6507_/A _6548_/D VDD VSS sg13cmos5l_nor2_1
X_6438_ _6445_/A _6438_/A _6438_/B VDD VSS sg13cmos5l_nand2_2
Xmax_cap981 _4023_/A wire982/X VDD VSS sg13cmos5l_buf_8
Xmax_cap992 _5641_/B1 _5334_/A VDD VSS sg13cmos5l_buf_2
XFILLER_88_521 VDD VSS sg13cmos5l_fill_1
XFILLER_76_716 VDD VSS sg13cmos5l_fill_1
XFILLER_76_749 VDD VSS sg13cmos5l_fill_2
XFILLER_76_738 VDD VSS sg13cmos5l_fill_1
XFILLER_75_237 VDD VSS sg13cmos5l_decap_8
XFILLER_56_440 VDD VSS sg13cmos5l_fill_2
XFILLER_75_259 VDD VSS sg13cmos5l_decap_8
XFILLER_44_602 VDD VSS sg13cmos5l_fill_2
XFILLER_72_900 VDD VSS sg13cmos5l_decap_8
XFILLER_84_793 VDD VSS sg13cmos5l_decap_8
XFILLER_45_98 VDD VSS sg13cmos5l_decap_4
XFILLER_71_465 VDD VSS sg13cmos5l_decap_8
XFILLER_40_830 VDD VSS sg13cmos5l_decap_8
XFILLER_61_53 VDD VSS sg13cmos5l_fill_1
XANTENNA_8 input824/X VDD VSS sg13cmos5l_antennanp
XFILLER_79_510 VDD VSS sg13cmos5l_fill_2
XFILLER_66_204 VDD VSS sg13cmos5l_fill_1
XFILLER_86_50 VDD VSS sg13cmos5l_fill_1
XFILLER_13_6 VDD VSS sg13cmos5l_fill_1
Xinput860 _4114_/B quant_cfg[8] VDD VSS sg13cmos5l_buf_1
XFILLER_81_207 VDD VSS sg13cmos5l_fill_1
XFILLER_75_793 VDD VSS sg13cmos5l_decap_8
XFILLER_50_605 VDD VSS sg13cmos5l_fill_2
XFILLER_50_638 VDD VSS sg13cmos5l_decap_8
X_5740_ _5774_/A _5693_/B _5693_/A _5739_/Y VDD VSS sg13cmos5l_a21oi_1
X_7410_ _7411_/A _7410_/A _7438_/A VDD VSS sg13cmos5l_nand2_1
X_5671_ _5733_/A _5927_/A _5670_/Y _5609_/B VDD VSS sg13cmos5l_o21ai_1
X_4622_ _4625_/A _4674_/S _4622_/B VDD VSS sg13cmos5l_xnor2_1
X_7341_ _7524_/A _7335_/A _7380_/B VDD VSS sg13cmos5l_nand2b_1
X_4553_ _4553_/Y _4553_/A _4553_/B VDD VSS sg13cmos5l_nand2_1
X_7272_ _7304_/A _7530_/B _7530_/A VDD VSS sg13cmos5l_nor2b_2
X_4484_ _4550_/A _4463_/B _4463_/A _4483_/Y VDD VSS sg13cmos5l_a21o_1
X_6223_ _6223_/Y _6223_/A _6223_/B VDD VSS sg13cmos5l_nand2_1
X_6154_ _6157_/A _6170_/B _6170_/A VDD VSS sg13cmos5l_xor2_1
X_6085_ _6117_/A _6085_/A _6085_/B VDD VSS sg13cmos5l_xnor2_1
X_5105_ _5106_/B _5105_/A _5105_/B VDD VSS sg13cmos5l_nand2_2
X_5036_ _5105_/B _5036_/A _5103_/A VDD VSS sg13cmos5l_xor2_1
XFILLER_122_15 VDD VSS sg13cmos5l_decap_4
XFILLER_82_19 VDD VSS sg13cmos5l_fill_1
X_6987_ _6989_/A _6987_/A _6987_/B VDD VSS sg13cmos5l_nand2_2
XFILLER_81_763 VDD VSS sg13cmos5l_decap_8
X_5938_ _6010_/B _5938_/A _5925_/A VDD VSS sg13cmos5l_nor2b_1
X_5869_ _5870_/B _6136_/B _5869_/A2 _6084_/B1 _5869_/B2 VDD VSS sg13cmos5l_a22oi_1
X_7608_ _7609_/A _7608_/A _7608_/B VDD VSS sg13cmos5l_nand2_2
X_7539_ _7539_/Y _7539_/A1 _7536_/A _7217_/B VDD VSS sg13cmos5l_a21oi_1
XFILLER_88_351 VDD VSS sg13cmos5l_decap_4
XFILLER_48_226 VDD VSS sg13cmos5l_decap_4
XFILLER_45_911 VDD VSS sg13cmos5l_decap_8
XFILLER_57_793 VDD VSS sg13cmos5l_decap_8
XFILLER_84_590 VDD VSS sg13cmos5l_decap_8
XFILLER_72_41 VDD VSS sg13cmos5l_fill_2
XFILLER_72_74 VDD VSS sg13cmos5l_fill_2
XFILLER_72_85 VDD VSS sg13cmos5l_decap_8
XFILLER_40_682 VDD VSS sg13cmos5l_fill_1
XFILLER_67_524 VDD VSS sg13cmos5l_fill_2
XFILLER_79_362 VDD VSS sg13cmos5l_fill_2
XFILLER_39_226 VDD VSS sg13cmos5l_fill_1
XFILLER_48_760 VDD VSS sg13cmos5l_decap_8
XFILLER_48_782 VDD VSS sg13cmos5l_fill_1
XFILLER_82_527 VDD VSS sg13cmos5l_decap_4
XFILLER_47_281 VDD VSS sg13cmos5l_fill_1
X_6910_ _7069_/A _6771_/Y _6766_/A _6929_/B VDD VSS sg13cmos5l_mux2_1
XFILLER_63_752 VDD VSS sg13cmos5l_decap_4
Xplace730 _5141_/A _4643_/A VDD VSS sg13cmos5l_buf_1
Xplace741 _5012_/A1 _3964_/A VDD VSS sg13cmos5l_buf_1
X_6841_ _6841_/X _6841_/A _6841_/B VDD VSS sg13cmos5l_xor2_1
XFILLER_62_284 VDD VSS sg13cmos5l_fill_1
Xplace752 place752/X place753/X VDD VSS sg13cmos5l_buf_1
X_6772_ _7028_/A _6770_/Y _6771_/Y _6929_/B VDD VSS sg13cmos5l_mux2_1
X_3984_ _3987_/B _3993_/B _3993_/A VDD VSS sg13cmos5l_xnor2_1
X_5723_ _5723_/Y _5723_/A _5653_/A VDD VSS sg13cmos5l_nor2b_1
X_5654_ _5656_/A _5654_/A _5593_/A VDD VSS sg13cmos5l_nor2b_1
X_4605_ _4607_/A _4614_/A _4614_/B VDD VSS sg13cmos5l_xnor2_1
X_7324_ _7551_/B _7324_/A _7720_/Q VDD VSS sg13cmos5l_nand2_1
X_5585_ _5586_/B _5459_/A _5585_/A2 _5395_/A _5585_/B2 VDD VSS sg13cmos5l_a22oi_1
Xrebuffer2011 _4253_/B _4228_/B VDD VSS sg13cmos5l_buf_1
Xrebuffer2000 _4196_/B_N _4179_/A VDD VSS sg13cmos5l_buf_1
X_4536_ _4558_/B _4599_/B _4599_/A VDD VSS sg13cmos5l_xor2_1
Xrebuffer2033 _7529_/B _7317_/A VDD VSS sg13cmos5l_buf_1
Xrebuffer2044 _6835_/B _6488_/A VDD VSS sg13cmos5l_buf_1
Xrebuffer2055 _6870_/A _6547_/A VDD VSS sg13cmos5l_buf_1
Xrebuffer1310 rebuffer1310/X rebuffer1311/X VDD VSS sg13cmos5l_buf_1
X_7255_ _7259_/A _7302_/A1 _7252_/Y _7254_/X VDD VSS sg13cmos5l_o21ai_1
X_4467_ _4468_/B _4467_/A _4467_/B VDD VSS sg13cmos5l_and2_1
Xrebuffer1343 rebuffer1343/X _7386_/A VDD VSS sg13cmos5l_buf_1
Xrebuffer1332 _6770_/B _6575_/A VDD VSS sg13cmos5l_buf_1
Xrebuffer1321 rebuffer1321/X rebuffer1322/X VDD VSS sg13cmos5l_buf_1
X_7186_ _7186_/Y _7186_/A _7296_/A VDD VSS sg13cmos5l_nand2_1
X_6206_ _6206_/Y _6209_/A1 _6204_/Y _6205_/Y VDD VSS sg13cmos5l_a21oi_1
X_4398_ _4461_/B _4457_/B _4457_/A VDD VSS sg13cmos5l_xor2_1
Xrebuffer1387 _7635_/B rebuffer1560/X VDD VSS sg13cmos5l_buf_1
Xrebuffer1376 _7318_/A _6925_/A VDD VSS sg13cmos5l_buf_1
Xrebuffer1365 rebuffer1365/X rebuffer1366/X VDD VSS sg13cmos5l_buf_1
Xrebuffer1354 rebuffer1354/X rebuffer1355/X VDD VSS sg13cmos5l_buf_1
X_6137_ _6138_/B _5460_/C _4496_/A _6136_/Y VDD VSS sg13cmos5l_o21ai_1
XFILLER_86_822 VDD VSS sg13cmos5l_decap_8
XFILLER_58_557 VDD VSS sg13cmos5l_decap_8
Xrebuffer1398 _7504_/A1 rebuffer1428/X VDD VSS sg13cmos5l_buf_1
XFILLER_39_771 VDD VSS sg13cmos5l_decap_8
X_6068_ _6068_/Y _6068_/A _6068_/B VDD VSS sg13cmos5l_nor2_1
XFILLER_86_899 VDD VSS sg13cmos5l_decap_8
X_5019_ _5020_/B _5070_/A _5070_/B VDD VSS sg13cmos5l_xor2_1
XFILLER_42_914 VDD VSS sg13cmos5l_decap_4
XFILLER_54_752 VDD VSS sg13cmos5l_fill_2
XFILLER_53_251 VDD VSS sg13cmos5l_decap_8
XFILLER_42_33 VDD VSS sg13cmos5l_decap_8
XFILLER_42_55 VDD VSS sg13cmos5l_fill_1
XFILLER_42_99 VDD VSS sg13cmos5l_decap_4
XFILLER_77_844 VDD VSS sg13cmos5l_decap_8
XFILLER_76_343 VDD VSS sg13cmos5l_decap_8
XFILLER_37_708 VDD VSS sg13cmos5l_decap_4
XFILLER_49_568 VDD VSS sg13cmos5l_decap_4
XFILLER_45_752 VDD VSS sg13cmos5l_fill_2
XFILLER_45_763 VDD VSS sg13cmos5l_fill_2
XFILLER_66_4 VDD VSS sg13cmos5l_fill_2
X_5370_ _5429_/S _5430_/B1 _5493_/A2 _5370_/B1 _5370_/B2 VDD VSS sg13cmos5l_a22oi_1
X_4321_ _4322_/B _4127_/A _3999_/A _4434_/B1 _4642_/B2 VDD VSS sg13cmos5l_a22oi_1
X_7040_ _7096_/C _6332_/A _7025_/Y _7350_/A2 _7327_/B VDD VSS sg13cmos5l_a22oi_1
X_4252_ _4252_/Y _4252_/A VDD VSS sg13cmos5l_inv_1
XFILLER_67_332 VDD VSS sg13cmos5l_decap_8
XFILLER_68_866 VDD VSS sg13cmos5l_decap_8
X_4183_ _4184_/A _4136_/B _4181_/Y _4182_/Y VDD VSS sg13cmos5l_o21ai_1
XFILLER_83_803 VDD VSS sg13cmos5l_decap_8
XFILLER_48_590 VDD VSS sg13cmos5l_fill_2
XFILLER_55_538 VDD VSS sg13cmos5l_fill_1
XFILLER_55_549 VDD VSS sg13cmos5l_decap_8
XFILLER_63_560 VDD VSS sg13cmos5l_fill_2
XFILLER_51_755 VDD VSS sg13cmos5l_decap_8
Xplace560 _4753_/A2 _4048_/A VDD VSS sg13cmos5l_buf_1
Xplace571 _3951_/A _4592_/A2 VDD VSS sg13cmos5l_buf_1
Xplace582 _7397_/A _6332_/A VDD VSS sg13cmos5l_buf_1
X_6824_ _6824_/X _6824_/A _6968_/B VDD VSS sg13cmos5l_and2_1
XFILLER_51_788 VDD VSS sg13cmos5l_fill_1
Xplace593 _7144_/B _6533_/B VDD VSS sg13cmos5l_buf_1
X_6755_ _7004_/B _6753_/Y _6754_/Y _6916_/B VDD VSS sg13cmos5l_mux2_1
X_3967_ _7661_/D _3967_/A _3970_/B VDD VSS sg13cmos5l_xnor2_1
XFILLER_50_298 VDD VSS sg13cmos5l_fill_2
X_5706_ _5706_/Y _5811_/A _5706_/B VDD VSS sg13cmos5l_nor2_1
X_6686_ _6687_/A _6721_/B _6721_/A VDD VSS sg13cmos5l_nand2_2
X_5637_ _5690_/B _5702_/A _5637_/B VDD VSS sg13cmos5l_xnor2_1
X_7307_ _7555_/B _7307_/A _7307_/B VDD VSS sg13cmos5l_nand2_1
X_4519_ _4535_/A _4453_/B _4453_/A _4518_/Y VDD VSS sg13cmos5l_a21oi_1
X_7238_ _7238_/Y _7327_/A _7238_/B VDD VSS sg13cmos5l_nor2_1
X_5499_ _5500_/B _5499_/A _5554_/A VDD VSS sg13cmos5l_xnor2_1
XFILLER_58_310 VDD VSS sg13cmos5l_fill_1
XFILLER_58_332 VDD VSS sg13cmos5l_fill_1
X_7169_ _7169_/Y _7020_/A _7187_/A _7296_/A VDD VSS sg13cmos5l_a21oi_1
XFILLER_46_516 VDD VSS sg13cmos5l_fill_2
XFILLER_59_877 VDD VSS sg13cmos5l_decap_8
XFILLER_58_387 VDD VSS sg13cmos5l_decap_8
XFILLER_58_398 VDD VSS sg13cmos5l_decap_4
XFILLER_73_335 VDD VSS sg13cmos5l_decap_8
XFILLER_74_836 VDD VSS sg13cmos5l_decap_8
XFILLER_86_696 VDD VSS sg13cmos5l_decap_8
XFILLER_37_88 VDD VSS sg13cmos5l_fill_1
XFILLER_81_390 VDD VSS sg13cmos5l_fill_1
XFILLER_42_788 VDD VSS sg13cmos5l_decap_8
XFILLER_78_51 VDD VSS sg13cmos5l_fill_2
XFILLER_68_129 VDD VSS sg13cmos5l_decap_4
XFILLER_77_630 VDD VSS sg13cmos5l_fill_1
XFILLER_77_674 VDD VSS sg13cmos5l_decap_8
XFILLER_64_335 VDD VSS sg13cmos5l_fill_2
XFILLER_65_836 VDD VSS sg13cmos5l_decap_8
XFILLER_73_880 VDD VSS sg13cmos5l_decap_8
XFILLER_72_390 VDD VSS sg13cmos5l_fill_1
X_4870_ _4881_/A _4931_/A _4870_/B VDD VSS sg13cmos5l_xnor2_1
X_6540_ _6554_/B _7688_/Q VDD VSS sg13cmos5l_inv_1
X_6471_ _6473_/A _6471_/A _6842_/A VDD VSS sg13cmos5l_nand2_2
X_5422_ _5485_/A _5361_/B _5362_/A _5421_/Y VDD VSS sg13cmos5l_o21ai_1
X_5353_ _5363_/A _5364_/B _5364_/A VDD VSS sg13cmos5l_xor2_1
X_4304_ _4363_/B _4360_/A VDD VSS sg13cmos5l_inv_1
X_5284_ _5285_/B _5284_/A _5347_/B VDD VSS sg13cmos5l_xor2_1
X_7023_ _7023_/Y _7078_/B _6789_/Y _7022_/Y VDD VSS sg13cmos5l_o21ai_1
X_4235_ _4236_/A _4235_/A VDD VSS sg13cmos5l_inv_1
X_4166_ _4196_/A _4134_/B _4134_/A _4165_/Y VDD VSS sg13cmos5l_a21oi_1
XFILLER_83_600 VDD VSS sg13cmos5l_decap_8
XFILLER_56_847 VDD VSS sg13cmos5l_decap_8
X_4097_ _4138_/A _4139_/A _4097_/B VDD VSS sg13cmos5l_xor2_1
XFILLER_83_677 VDD VSS sg13cmos5l_decap_8
XFILLER_82_143 VDD VSS sg13cmos5l_fill_1
XFILLER_51_563 VDD VSS sg13cmos5l_decap_4
X_6807_ _6807_/Y _6807_/A _6807_/B VDD VSS sg13cmos5l_nor2_1
X_4999_ _5006_/A _5060_/A _4999_/B VDD VSS sg13cmos5l_xnor2_1
X_6738_ _6739_/A _6916_/B _6732_/Y _6737_/Y VDD VSS sg13cmos5l_o21ai_1
X_6669_ _6743_/B _6659_/B _7701_/Q VDD VSS sg13cmos5l_nand2b_1
XFILLER_79_917 VDD VSS sg13cmos5l_fill_1
Xbank_A_sram.gen_ihp_256x32.u_sram_256x32_1184 bank_A_sram.gen_ihp_256x32.u_sram_256x32/A_BM[9]
+ VDD VSS sg13cmos5l_tiehi
Xbank_A_sram.gen_ihp_256x32.u_sram_256x32_1195 bank_A_sram.gen_ihp_256x32.u_sram_256x32/A_BM[20]
+ VDD VSS sg13cmos5l_tiehi
XFILLER_48_43 VDD VSS sg13cmos5l_decap_8
XFILLER_59_630 VDD VSS sg13cmos5l_fill_2
XFILLER_58_173 VDD VSS sg13cmos5l_decap_8
XFILLER_86_482 VDD VSS sg13cmos5l_decap_8
XFILLER_46_346 VDD VSS sg13cmos5l_fill_1
XFILLER_47_858 VDD VSS sg13cmos5l_decap_8
XFILLER_62_817 VDD VSS sg13cmos5l_decap_8
XFILLER_64_20 VDD VSS sg13cmos5l_fill_1
Xbank_B_sram.gen_ihp_256x32.u_sram_256x32_1160 bank_B_sram.gen_ihp_256x32.u_sram_256x32_1160/L_LO
+ VDD VSS sg13cmos5l_tielo
Xbank_B_sram.gen_ihp_256x32.u_sram_256x32_1171 bank_B_sram.gen_ihp_256x32.u_sram_256x32_1171/L_LO
+ VDD VSS sg13cmos5l_tielo
XFILLER_73_165 VDD VSS sg13cmos5l_fill_1
XFILLER_42_541 VDD VSS sg13cmos5l_fill_2
XFILLER_42_574 VDD VSS sg13cmos5l_fill_2
XFILLER_70_861 VDD VSS sg13cmos5l_decap_8
XFILLER_80_52 VDD VSS sg13cmos5l_fill_1
Xrebuffer1909 rebuffer1909/X rebuffer1910/X VDD VSS sg13cmos5l_buf_1
XFILLER_69_405 VDD VSS sg13cmos5l_fill_2
XFILLER_69_427 VDD VSS sg13cmos5l_decap_4
XFILLER_29_4 VDD VSS sg13cmos5l_fill_1
XFILLER_38_814 VDD VSS sg13cmos5l_decap_8
X_4020_ _4032_/A _4168_/A _4020_/B VDD VSS sg13cmos5l_xnor2_1
XFILLER_37_313 VDD VSS sg13cmos5l_decap_8
XFILLER_64_143 VDD VSS sg13cmos5l_fill_1
XFILLER_65_644 VDD VSS sg13cmos5l_fill_1
XFILLER_53_839 VDD VSS sg13cmos5l_decap_8
X_5971_ _6018_/A _5971_/A _5971_/B _5971_/C VDD VSS sg13cmos5l_nand3_1
XFILLER_80_625 VDD VSS sg13cmos5l_decap_8
XFILLER_64_187 VDD VSS sg13cmos5l_fill_1
X_7710_ _7710_/Q clkload9/A _7710_/D place749/X VDD VSS sg13cmos5l_dfrbpq_1
X_4922_ _4923_/B _4988_/A _4922_/B VDD VSS sg13cmos5l_xnor2_1
XFILLER_80_636 VDD VSS sg13cmos5l_fill_2
XFILLER_61_872 VDD VSS sg13cmos5l_decap_8
X_7641_ _7643_/A _7641_/A _7641_/B VDD VSS sg13cmos5l_nand2_1
X_4853_ _4909_/A _4853_/A _4853_/B VDD VSS sg13cmos5l_nor2_1
X_7572_ _7621_/D _7572_/A _7572_/B VDD VSS sg13cmos5l_xnor2_1
X_4784_ _4786_/A _4784_/A _4790_/A VDD VSS sg13cmos5l_xnor2_1
X_6523_ _6524_/B _6521_/B _7685_/Q VDD VSS sg13cmos5l_nand2b_1
X_6454_ _6847_/B _6454_/A _6454_/B VDD VSS sg13cmos5l_nand2_2
X_5405_ _5406_/B _5405_/A _5472_/B VDD VSS sg13cmos5l_xor2_1
X_6385_ _6826_/B _6385_/A _6385_/B VDD VSS sg13cmos5l_nand2_2
X_5336_ _5336_/Y _5336_/A _5336_/B VDD VSS sg13cmos5l_nor2_1
X_5267_ _5318_/A _5212_/B _5212_/A _5266_/Y VDD VSS sg13cmos5l_a21oi_1
XFILLER_87_235 VDD VSS sg13cmos5l_decap_8
XFILLER_87_213 VDD VSS sg13cmos5l_fill_2
X_7006_ _7006_/Y _7006_/A _7006_/B VDD VSS sg13cmos5l_nand2_1
X_4218_ _4219_/C _4218_/A VDD VSS sg13cmos5l_inv_1
XFILLER_87_279 VDD VSS sg13cmos5l_decap_8
X_5198_ _5253_/A _5152_/B _5152_/A _5197_/Y VDD VSS sg13cmos5l_a21oi_1
XFILLER_44_806 VDD VSS sg13cmos5l_decap_8
X_4149_ _4235_/A _4149_/A _4149_/B VDD VSS sg13cmos5l_nor2_1
XFILLER_70_157 VDD VSS sg13cmos5l_decap_4
XFILLER_52_894 VDD VSS sg13cmos5l_decap_8
XFILLER_51_393 VDD VSS sg13cmos5l_fill_1
Xclkload0 clkload0/Y clkload0/A VDD VSS sg13cmos5l_inv_1
XFILLER_50_88 VDD VSS sg13cmos5l_fill_2
XFILLER_67_909 VDD VSS sg13cmos5l_decap_8
XFILLER_78_257 VDD VSS sg13cmos5l_decap_8
XFILLER_87_780 VDD VSS sg13cmos5l_decap_8
XFILLER_46_110 VDD VSS sg13cmos5l_decap_8
XFILLER_75_96 VDD VSS sg13cmos5l_fill_2
XFILLER_75_85 VDD VSS sg13cmos5l_decap_8
XFILLER_62_658 VDD VSS sg13cmos5l_fill_2
XFILLER_43_850 VDD VSS sg13cmos5l_decap_8
XFILLER_61_179 VDD VSS sg13cmos5l_fill_1
X_6170_ _6170_/X _6170_/A _6170_/B VDD VSS sg13cmos5l_and2_1
X_5121_ _5122_/B _5432_/A _5121_/B VDD VSS sg13cmos5l_xnor2_1
XFILLER_57_408 VDD VSS sg13cmos5l_fill_1
XFILLER_58_909 VDD VSS sg13cmos5l_decap_8
X_5052_ _5053_/B _5432_/A _5052_/B VDD VSS sg13cmos5l_xnor2_1
XFILLER_37_121 VDD VSS sg13cmos5l_fill_1
X_4003_ _4004_/C _4003_/A VDD VSS sg13cmos5l_inv_1
XFILLER_38_688 VDD VSS sg13cmos5l_decap_8
XFILLER_37_187 VDD VSS sg13cmos5l_decap_4
XFILLER_52_124 VDD VSS sg13cmos5l_fill_1
XFILLER_53_658 VDD VSS sg13cmos5l_fill_1
X_5954_ _5955_/B _5954_/A _5973_/A VDD VSS sg13cmos5l_xnor2_1
X_5885_ _5885_/Y _5885_/A VDD VSS sg13cmos5l_inv_1
X_4905_ _4905_/Y _4905_/A _4841_/B VDD VSS sg13cmos5l_nor2b_1
X_7624_ _7625_/B _7624_/A _7624_/B _7624_/C _7624_/D VDD VSS sg13cmos5l_nand4_1
X_4836_ _4840_/A _4900_/B _4836_/B VDD VSS sg13cmos5l_xnor2_1
X_7555_ _7556_/B _7555_/A _7555_/B VDD VSS sg13cmos5l_nand2_1
X_6506_ _6513_/A _6506_/A _6506_/B VDD VSS sg13cmos5l_nand2_2
X_4767_ _4768_/B _4947_/A _4767_/B _4767_/C VDD VSS sg13cmos5l_nor3_1
X_7486_ _7488_/A _7605_/A _7605_/B VDD VSS sg13cmos5l_nand2_1
X_4698_ _4708_/A _5141_/A _4698_/B VDD VSS sg13cmos5l_xnor2_1
X_6437_ _6438_/B _6434_/B _7675_/Q VDD VSS sg13cmos5l_nand2b_1
X_6368_ _6379_/A _6368_/A _6368_/B _6368_/C VDD VSS sg13cmos5l_nand3_1
X_5319_ _5344_/A _5283_/B _5283_/A _5318_/Y VDD VSS sg13cmos5l_a21oi_1
X_6299_ _6301_/A _6299_/A _6299_/B VDD VSS sg13cmos5l_nand2_2
XFILLER_56_474 VDD VSS sg13cmos5l_fill_2
XFILLER_84_772 VDD VSS sg13cmos5l_decap_8
XFILLER_71_444 VDD VSS sg13cmos5l_decap_8
XFILLER_51_190 VDD VSS sg13cmos5l_fill_1
XFILLER_52_691 VDD VSS sg13cmos5l_fill_2
XFILLER_40_886 VDD VSS sg13cmos5l_decap_8
XANTENNA_9 input828/X VDD VSS sg13cmos5l_antennanp
XFILLER_67_706 VDD VSS sg13cmos5l_fill_2
XFILLER_20_8 VDD VSS sg13cmos5l_decap_8
XFILLER_79_588 VDD VSS sg13cmos5l_decap_4
Xinput850 _7715_/D quant_cfg[24] VDD VSS sg13cmos5l_buf_1
XFILLER_75_750 VDD VSS sg13cmos5l_fill_2
XFILLER_75_772 VDD VSS sg13cmos5l_decap_8
XFILLER_42_190 VDD VSS sg13cmos5l_decap_8
X_5670_ _5670_/Y _5670_/A VDD VSS sg13cmos5l_inv_1
XFILLER_96_4 VDD VSS sg13cmos5l_fill_1
X_4621_ _4622_/B _4988_/A _4621_/B VDD VSS sg13cmos5l_xnor2_1
X_7340_ _7342_/B _7380_/B _7347_/A VDD VSS sg13cmos5l_xnor2_1
X_4552_ _4552_/Y _4552_/A VDD VSS sg13cmos5l_inv_1
X_7271_ _7530_/A _7307_/B _7557_/B VDD VSS sg13cmos5l_xnor2_1
X_4483_ _4483_/Y _4483_/A _4464_/B VDD VSS sg13cmos5l_nor2b_1
X_6222_ _6222_/Y _6210_/A _6198_/Y _6221_/Y VDD VSS sg13cmos5l_o21ai_1
X_6153_ _6170_/A _6175_/B _6128_/B _6152_/Y VDD VSS sg13cmos5l_o21ai_1
X_6084_ _6085_/B _6136_/B _6084_/A2 _6084_/B1 _6084_/B2 VDD VSS sg13cmos5l_a22oi_1
X_5104_ _5104_/Y _5104_/A _5036_/A VDD VSS sg13cmos5l_nor2b_1
XFILLER_57_227 VDD VSS sg13cmos5l_decap_4
X_5035_ _5103_/A _5035_/A _5035_/B VDD VSS sg13cmos5l_and2_1
XFILLER_85_569 VDD VSS sg13cmos5l_decap_8
XFILLER_54_901 VDD VSS sg13cmos5l_decap_8
XFILLER_38_485 VDD VSS sg13cmos5l_decap_8
XFILLER_53_433 VDD VSS sg13cmos5l_decap_8
XFILLER_65_271 VDD VSS sg13cmos5l_decap_4
XFILLER_81_742 VDD VSS sg13cmos5l_decap_8
X_6986_ _6987_/B _7714_/Q _6986_/B VDD VSS sg13cmos5l_xnor2_1
XFILLER_41_628 VDD VSS sg13cmos5l_decap_4
X_5937_ _5938_/A _5937_/A VDD VSS sg13cmos5l_inv_1
X_7607_ _7608_/B _7607_/A _7607_/B VDD VSS sg13cmos5l_xnor2_1
X_5868_ _5874_/A _5982_/A _5868_/B VDD VSS sg13cmos5l_xnor2_1
X_5799_ _5800_/B _5799_/A _5852_/A VDD VSS sg13cmos5l_xnor2_1
X_4819_ _4867_/A _4773_/B _4773_/A _4818_/Y VDD VSS sg13cmos5l_a21oi_1
X_7538_ _7614_/B _7538_/A _7538_/B VDD VSS sg13cmos5l_xor2_1
X_7469_ _7473_/A _7469_/A _7475_/B VDD VSS sg13cmos5l_nor2b_1
XFILLER_88_374 VDD VSS sg13cmos5l_decap_4
XFILLER_48_249 VDD VSS sg13cmos5l_fill_2
XFILLER_57_761 VDD VSS sg13cmos5l_decap_4
XFILLER_63_208 VDD VSS sg13cmos5l_fill_1
XFILLER_56_282 VDD VSS sg13cmos5l_decap_8
XFILLER_56_98 VDD VSS sg13cmos5l_decap_8
XFILLER_44_455 VDD VSS sg13cmos5l_decap_8
XFILLER_44_466 VDD VSS sg13cmos5l_fill_1
XFILLER_72_64 VDD VSS sg13cmos5l_fill_2
XFILLER_67_503 VDD VSS sg13cmos5l_decap_8
XFILLER_39_249 VDD VSS sg13cmos5l_fill_2
XFILLER_47_271 VDD VSS sg13cmos5l_fill_1
Xplace720 _6223_/A _6210_/A VDD VSS sg13cmos5l_buf_1
Xplace731 _4643_/A _4322_/A VDD VSS sg13cmos5l_buf_1
X_6840_ _6840_/Y _6941_/B _6941_/A _6839_/Y VDD VSS sg13cmos5l_o21ai_1
XFILLER_50_403 VDD VSS sg13cmos5l_fill_1
XFILLER_63_775 VDD VSS sg13cmos5l_fill_2
XFILLER_63_797 VDD VSS sg13cmos5l_fill_1
Xplace742 _5517_/A _3964_/A VDD VSS sg13cmos5l_buf_1
Xplace753 place753/X place754/X VDD VSS sg13cmos5l_buf_1
X_6771_ _6771_/Y _6771_/A _6771_/B VDD VSS sg13cmos5l_xnor2_1
X_5722_ _5722_/Y _5722_/A VDD VSS sg13cmos5l_inv_1
X_3983_ _3993_/A _5645_/A _3983_/B VDD VSS sg13cmos5l_xnor2_1
X_5653_ _5657_/A _5653_/A _5723_/A VDD VSS sg13cmos5l_xnor2_1
X_5584_ _5709_/B _5710_/B VDD VSS sg13cmos5l_inv_1
X_4604_ _4614_/B _4604_/A _4604_/B VDD VSS sg13cmos5l_xor2_1
X_7323_ _7550_/B _7323_/A _7720_/Q VDD VSS sg13cmos5l_nand2_1
X_4535_ _4599_/A _4535_/A _4598_/A VDD VSS sg13cmos5l_xnor2_1
Xrebuffer2012 _4037_/B _4011_/B VDD VSS sg13cmos5l_buf_1
Xrebuffer2001 _4213_/A1 _4178_/B VDD VSS sg13cmos5l_buf_1
Xrebuffer1300 rebuffer1300/X rebuffer1301/X VDD VSS sg13cmos5l_buf_1
Xrebuffer2034 _7646_/A1 _7123_/A VDD VSS sg13cmos5l_buf_1
Xrebuffer2045 _6787_/B _6319_/A VDD VSS sg13cmos5l_buf_1
Xrebuffer1311 rebuffer1311/X rebuffer1312/X VDD VSS sg13cmos5l_buf_1
X_7254_ _7254_/X _7253_/Y _7301_/A2 _7059_/Y VDD VSS sg13cmos5l_a21o_1
X_4466_ _4473_/B _4469_/B VDD VSS sg13cmos5l_inv_1
Xrebuffer2056 _6811_/B _6350_/A VDD VSS sg13cmos5l_buf_1
Xrebuffer1344 rebuffer1344/X rebuffer1345/X VDD VSS sg13cmos5l_buf_1
Xrebuffer1333 _6878_/A1 _6505_/A VDD VSS sg13cmos5l_buf_1
Xrebuffer1322 rebuffer1322/X _7043_/A VDD VSS sg13cmos5l_buf_1
X_7185_ _7186_/A _6951_/A _7086_/Y _7184_/Y VDD VSS sg13cmos5l_o21ai_1
X_6205_ _6205_/Y _6205_/A _6205_/B VDD VSS sg13cmos5l_nor2_1
X_4397_ _4457_/A _4397_/A _4456_/A VDD VSS sg13cmos5l_xnor2_1
Xrebuffer1377 rebuffer1377/X rebuffer1378/X VDD VSS sg13cmos5l_buf_1
Xrebuffer1366 rebuffer1366/X rebuffer1367/X VDD VSS sg13cmos5l_buf_1
Xrebuffer1355 rebuffer1355/X rebuffer1356/X VDD VSS sg13cmos5l_buf_1
X_6136_ _6136_/Y _6136_/A _6136_/B VDD VSS sg13cmos5l_nand2_1
XFILLER_86_801 VDD VSS sg13cmos5l_decap_8
Xrebuffer1399 _7534_/A1 _7245_/A VDD VSS sg13cmos5l_buf_1
Xrebuffer1388 _6275_/B _6265_/A VDD VSS sg13cmos5l_buf_2
X_6067_ _6067_/Y _6067_/A VDD VSS sg13cmos5l_inv_1
XFILLER_86_878 VDD VSS sg13cmos5l_decap_8
XFILLER_85_366 VDD VSS sg13cmos5l_fill_2
X_5018_ _5070_/B _5018_/A _5018_/B VDD VSS sg13cmos5l_xnor2_1
X_6969_ _7078_/A _6811_/Y _6955_/B _6968_/X VDD VSS sg13cmos5l_a21oi_1
XFILLER_67_20 VDD VSS sg13cmos5l_fill_2
XFILLER_77_823 VDD VSS sg13cmos5l_decap_8
XFILLER_67_75 VDD VSS sg13cmos5l_decap_8
XFILLER_76_322 VDD VSS sg13cmos5l_fill_2
XFILLER_76_399 VDD VSS sg13cmos5l_decap_8
X_4320_ _4334_/A _4282_/B _4282_/A _4319_/Y VDD VSS sg13cmos5l_a21oi_1
X_4251_ _4295_/B _6022_/A _4251_/B VDD VSS sg13cmos5l_nor2_1
XFILLER_67_300 VDD VSS sg13cmos5l_decap_8
Xclkbuf_regs_0_clk_i clkbuf_regs_0_clk_i/X clk_i VDD VSS sg13cmos5l_buf_16
XFILLER_68_845 VDD VSS sg13cmos5l_decap_8
X_4182_ _4182_/Y _4135_/B _4182_/B VDD VSS sg13cmos5l_nand2b_1
XFILLER_55_517 VDD VSS sg13cmos5l_fill_2
XFILLER_67_355 VDD VSS sg13cmos5l_fill_1
XFILLER_83_859 VDD VSS sg13cmos5l_decap_8
XFILLER_50_200 VDD VSS sg13cmos5l_decap_4
XFILLER_63_572 VDD VSS sg13cmos5l_fill_1
Xplace550 _5385_/A2 _5871_/A2 VDD VSS sg13cmos5l_buf_1
Xplace561 _4048_/A _4045_/Y VDD VSS sg13cmos5l_buf_1
Xplace572 _4592_/A2 _4175_/A2 VDD VSS sg13cmos5l_buf_1
Xplace583 _7054_/B _7072_/B VDD VSS sg13cmos5l_buf_1
X_6823_ _6824_/A _6823_/A _6823_/B VDD VSS sg13cmos5l_xnor2_1
XFILLER_50_266 VDD VSS sg13cmos5l_decap_4
Xplace594 _6533_/B _6548_/B VDD VSS sg13cmos5l_buf_8
X_6754_ _6754_/Y _6754_/A _6754_/B VDD VSS sg13cmos5l_xnor2_1
X_3966_ _3970_/B _3966_/A _3966_/B _3966_/C VDD VSS sg13cmos5l_nand3_1
X_6685_ _6721_/A _6685_/A _6687_/B VDD VSS sg13cmos5l_nor2b_1
X_5705_ _5811_/A _5705_/A VDD VSS sg13cmos5l_inv_1
XFILLER_12_15 VDD VSS sg13cmos5l_decap_4
X_5636_ _5637_/B _5985_/B1 _5871_/A2 _5760_/B1 _5871_/B2 VDD VSS sg13cmos5l_a22oi_1
X_5567_ _5593_/A _5526_/A _5565_/Y _5566_/Y VDD VSS sg13cmos5l_o21ai_1
X_7306_ _7308_/A _7306_/A _7307_/B VDD VSS sg13cmos5l_nand2_1
X_5498_ _5554_/A _5452_/B _5452_/A _5497_/X VDD VSS sg13cmos5l_a21oi_1
X_4518_ _4518_/Y _4518_/A _4518_/B VDD VSS sg13cmos5l_nor2_1
X_7237_ _7238_/B _7296_/A _7237_/B VDD VSS sg13cmos5l_nor2_1
X_4449_ _4518_/A _4525_/B _4389_/A _4448_/Y VDD VSS sg13cmos5l_a21o_1
XFILLER_59_856 VDD VSS sg13cmos5l_decap_8
X_7168_ _7168_/Y _7016_/B _7168_/B VDD VSS sg13cmos5l_nand2b_1
XFILLER_37_23 VDD VSS sg13cmos5l_decap_8
XFILLER_74_815 VDD VSS sg13cmos5l_decap_8
X_7099_ _7099_/Y _6877_/A _6877_/B _7191_/B VDD VSS sg13cmos5l_a21oi_1
X_6119_ _6145_/A _6142_/B _6119_/B VDD VSS sg13cmos5l_xnor2_1
XFILLER_86_675 VDD VSS sg13cmos5l_decap_8
XFILLER_82_881 VDD VSS sg13cmos5l_decap_8
XFILLER_41_211 VDD VSS sg13cmos5l_fill_2
XFILLER_42_767 VDD VSS sg13cmos5l_decap_8
XFILLER_53_66 VDD VSS sg13cmos5l_fill_1
XFILLER_53_88 VDD VSS sg13cmos5l_decap_8
XFILLER_78_74 VDD VSS sg13cmos5l_fill_1
XFILLER_78_96 VDD VSS sg13cmos5l_fill_1
XFILLER_77_653 VDD VSS sg13cmos5l_decap_8
XFILLER_37_517 VDD VSS sg13cmos5l_decap_8
XFILLER_64_303 VDD VSS sg13cmos5l_decap_8
XFILLER_76_185 VDD VSS sg13cmos5l_decap_4
XFILLER_45_550 VDD VSS sg13cmos5l_decap_4
XFILLER_45_572 VDD VSS sg13cmos5l_decap_8
XFILLER_80_829 VDD VSS sg13cmos5l_decap_8
XFILLER_72_380 VDD VSS sg13cmos5l_decap_4
XFILLER_60_553 VDD VSS sg13cmos5l_fill_1
XFILLER_60_597 VDD VSS sg13cmos5l_fill_1
X_6470_ _6842_/A _7679_/Q _6470_/B VDD VSS sg13cmos5l_xnor2_1
X_5421_ _5421_/Y _5357_/A _5359_/Y _5357_/B VDD VSS sg13cmos5l_o21ai_1
X_5352_ _5364_/A _5290_/B _5290_/A _5351_/X VDD VSS sg13cmos5l_a21o_1
X_4303_ _4360_/A _4303_/A _4303_/B VDD VSS sg13cmos5l_nand2_1
X_7022_ _7022_/Y _6801_/Y _7078_/B _6807_/A VDD VSS sg13cmos5l_a21oi_1
X_5283_ _5347_/B _5283_/A _5283_/B VDD VSS sg13cmos5l_xor2_1
X_4234_ _4234_/Y _4234_/A VDD VSS sg13cmos5l_inv_1
XFILLER_68_642 VDD VSS sg13cmos5l_decap_8
XFILLER_68_664 VDD VSS sg13cmos5l_decap_8
X_4165_ _4165_/Y _4165_/A _4165_/B VDD VSS sg13cmos5l_nor2_1
XFILLER_56_826 VDD VSS sg13cmos5l_decap_8
XFILLER_67_185 VDD VSS sg13cmos5l_decap_8
X_4096_ _4139_/A _4064_/Y _4072_/A _4095_/Y VDD VSS sg13cmos5l_a21o_1
XFILLER_83_656 VDD VSS sg13cmos5l_decap_8
XFILLER_43_509 VDD VSS sg13cmos5l_decap_8
XFILLER_70_317 VDD VSS sg13cmos5l_decap_4
X_6806_ _6807_/B _6977_/B _6803_/Y _6978_/B _6805_/Y VDD VSS sg13cmos5l_a22oi_1
X_4998_ _4999_/B _5310_/B1 _5380_/A2 _5244_/B1 _5188_/B2 VDD VSS sg13cmos5l_a22oi_1
X_6737_ _6737_/Y _6904_/B _6916_/B VDD VSS sg13cmos5l_nand2_1
X_6668_ _6742_/A _6668_/A VDD VSS sg13cmos5l_inv_1
X_6599_ _6764_/A _6599_/A _6601_/B VDD VSS sg13cmos5l_nor2b_1
X_5619_ _5619_/Y _5619_/A _5563_/A VDD VSS sg13cmos5l_nor2b_1
Xbank_A_sram.gen_ihp_256x32.u_sram_256x32_1185 bank_A_sram.gen_ihp_256x32.u_sram_256x32/A_BM[10]
+ VDD VSS sg13cmos5l_tiehi
Xbank_A_sram.gen_ihp_256x32.u_sram_256x32_1196 bank_A_sram.gen_ihp_256x32.u_sram_256x32/A_BM[21]
+ VDD VSS sg13cmos5l_tiehi
XFILLER_48_66 VDD VSS sg13cmos5l_fill_2
XFILLER_46_303 VDD VSS sg13cmos5l_fill_1
XFILLER_47_837 VDD VSS sg13cmos5l_decap_8
XFILLER_74_612 VDD VSS sg13cmos5l_decap_4
XFILLER_86_461 VDD VSS sg13cmos5l_fill_1
Xbank_B_sram.gen_ihp_256x32.u_sram_256x32_1150 bank_B_sram.gen_ihp_256x32.u_sram_256x32_1150/L_LO
+ VDD VSS sg13cmos5l_tielo
Xbank_B_sram.gen_ihp_256x32.u_sram_256x32_1161 bank_B_sram.gen_ihp_256x32.u_sram_256x32_1161/L_LO
+ VDD VSS sg13cmos5l_tielo
Xbank_B_sram.gen_ihp_256x32.u_sram_256x32_1172 bank_B_sram.gen_ihp_256x32.u_sram_256x32_1172/L_LO
+ VDD VSS sg13cmos5l_tielo
XFILLER_55_881 VDD VSS sg13cmos5l_decap_8
XFILLER_70_840 VDD VSS sg13cmos5l_decap_8
XFILLER_73_199 VDD VSS sg13cmos5l_fill_2
XFILLER_80_31 VDD VSS sg13cmos5l_fill_2
XFILLER_80_97 VDD VSS sg13cmos5l_fill_1
XFILLER_49_152 VDD VSS sg13cmos5l_decap_8
XFILLER_37_336 VDD VSS sg13cmos5l_fill_2
XFILLER_53_807 VDD VSS sg13cmos5l_fill_1
XFILLER_64_122 VDD VSS sg13cmos5l_fill_2
XFILLER_65_634 VDD VSS sg13cmos5l_fill_1
XFILLER_65_678 VDD VSS sg13cmos5l_decap_8
X_5970_ _5972_/A _5971_/A _5971_/B _5971_/C VDD VSS sg13cmos5l_a21oi_1
XFILLER_80_604 VDD VSS sg13cmos5l_fill_2
X_4921_ _4922_/B _5117_/B1 _5179_/A2 _5050_/B1 _5246_/B2 VDD VSS sg13cmos5l_a22oi_1
XFILLER_61_851 VDD VSS sg13cmos5l_decap_8
X_7640_ _7723_/D _7640_/A _7658_/B VDD VSS sg13cmos5l_nand2_2
X_4852_ _4853_/B _4852_/A VDD VSS sg13cmos5l_inv_1
X_7571_ _7572_/B _7571_/A _7571_/B VDD VSS sg13cmos5l_nand2_1
X_4783_ _4790_/A _4792_/A _4791_/A VDD VSS sg13cmos5l_xnor2_1
X_6522_ _6524_/A _6883_/B _6883_/A VDD VSS sg13cmos5l_nand2_2
X_6453_ _6454_/A _6848_/B _6848_/A VDD VSS sg13cmos5l_nand2_2
X_5404_ _5472_/B _5404_/A _5404_/B VDD VSS sg13cmos5l_xor2_1
X_6384_ _6385_/B _6382_/A _7670_/Q VDD VSS sg13cmos5l_nand2b_1
X_5335_ _5336_/B _5335_/A _5335_/B _5335_/C VDD VSS sg13cmos5l_nor3_1
X_5266_ _5266_/Y _5266_/A _5266_/B VDD VSS sg13cmos5l_nor2_1
X_7005_ _7006_/A _6739_/A _7004_/A _7004_/Y VDD VSS sg13cmos5l_a21oi_1
X_4217_ _4220_/A _3972_/A _4218_/A _3976_/B VDD VSS sg13cmos5l_a21oi_1
XFILLER_56_601 VDD VSS sg13cmos5l_decap_8
X_5197_ _5197_/Y _5197_/A _5197_/B VDD VSS sg13cmos5l_nor2_1
XFILLER_56_634 VDD VSS sg13cmos5l_decap_8
XFILLER_56_656 VDD VSS sg13cmos5l_fill_2
X_4148_ _4149_/B _4148_/A VDD VSS sg13cmos5l_inv_1
XFILLER_43_317 VDD VSS sg13cmos5l_decap_8
XFILLER_55_144 VDD VSS sg13cmos5l_fill_2
X_4079_ _4079_/Y _4079_/A _4079_/B VDD VSS sg13cmos5l_nor2_1
XFILLER_55_199 VDD VSS sg13cmos5l_decap_8
XFILLER_52_873 VDD VSS sg13cmos5l_decap_8
XFILLER_70_136 VDD VSS sg13cmos5l_decap_8
XFILLER_51_361 VDD VSS sg13cmos5l_decap_4
Xclkload1 clkload1/Y clkload1/A VDD VSS sg13cmos5l_inv_1
XFILLER_50_45 VDD VSS sg13cmos5l_decap_8
XFILLER_50_56 VDD VSS sg13cmos5l_fill_1
XFILLER_50_67 VDD VSS sg13cmos5l_fill_2
XFILLER_78_236 VDD VSS sg13cmos5l_fill_1
XFILLER_78_203 VDD VSS sg13cmos5l_decap_8
XFILLER_46_144 VDD VSS sg13cmos5l_fill_1
XFILLER_46_166 VDD VSS sg13cmos5l_decap_8
XFILLER_47_678 VDD VSS sg13cmos5l_decap_8
XFILLER_47_689 VDD VSS sg13cmos5l_fill_2
XFILLER_62_615 VDD VSS sg13cmos5l_fill_2
XFILLER_74_475 VDD VSS sg13cmos5l_decap_4
XFILLER_70_692 VDD VSS sg13cmos5l_decap_4
X_5120_ _5121_/B _5310_/B1 _5179_/A2 _5244_/B1 _5246_/B2 VDD VSS sg13cmos5l_a22oi_1
X_5051_ _5052_/B _5244_/B1 _5179_/A2 _5178_/B1 _5246_/B2 VDD VSS sg13cmos5l_a22oi_1
XFILLER_38_612 VDD VSS sg13cmos5l_decap_8
XFILLER_38_623 VDD VSS sg13cmos5l_fill_2
X_4002_ _4005_/A _3955_/A _4003_/A _3976_/B VDD VSS sg13cmos5l_a21oi_1
XFILLER_37_144 VDD VSS sg13cmos5l_fill_1
XFILLER_65_453 VDD VSS sg13cmos5l_decap_4
XFILLER_53_626 VDD VSS sg13cmos5l_decap_8
XFILLER_65_486 VDD VSS sg13cmos5l_decap_4
XFILLER_80_423 VDD VSS sg13cmos5l_decap_8
X_5953_ _5973_/A _5905_/B _5906_/A _5903_/Y VDD VSS sg13cmos5l_a21oi_1
XFILLER_80_467 VDD VSS sg13cmos5l_decap_8
X_5884_ _5933_/B _5884_/A _5884_/B VDD VSS sg13cmos5l_xnor2_1
X_4904_ _4969_/B _4904_/A _4904_/B VDD VSS sg13cmos5l_xor2_1
X_7623_ _7624_/D _7623_/A _7623_/B _7623_/C _7623_/D VDD VSS sg13cmos5l_nor4_1
X_4835_ _4836_/B _4835_/A _4901_/B VDD VSS sg13cmos5l_xor2_1
X_7554_ _7555_/A _7554_/A _7554_/B VDD VSS sg13cmos5l_nand2_1
X_4766_ _4767_/C _4766_/A VDD VSS sg13cmos5l_inv_1
X_6505_ _6506_/A _6505_/A _6505_/B _6836_/B VDD VSS sg13cmos5l_nand3_1
XFILLER_20_15 VDD VSS sg13cmos5l_decap_4
X_7485_ _7728_/D _7485_/A _7485_/B VDD VSS sg13cmos5l_nand2_2
X_4697_ _4698_/B _4762_/B1 _5009_/A2 _4697_/B1 _5140_/B2 VDD VSS sg13cmos5l_a22oi_1
X_6436_ _6438_/A _6436_/A _6436_/B _6820_/B VDD VSS sg13cmos5l_nand3_1
X_6367_ _6367_/Y _6368_/B _6368_/C _6368_/A VDD VSS sg13cmos5l_a21oi_1
X_5318_ _5318_/Y _5318_/A _5282_/B VDD VSS sg13cmos5l_nor2b_1
X_6298_ _6299_/B _7662_/Q _6298_/B VDD VSS sg13cmos5l_xnor2_1
X_5249_ _5249_/X _5249_/A _5249_/B VDD VSS sg13cmos5l_and2_1
XFILLER_56_420 VDD VSS sg13cmos5l_fill_2
XFILLER_44_604 VDD VSS sg13cmos5l_fill_1
XFILLER_56_442 VDD VSS sg13cmos5l_fill_1
XFILLER_84_751 VDD VSS sg13cmos5l_decap_8
XFILLER_43_103 VDD VSS sg13cmos5l_decap_4
XFILLER_43_125 VDD VSS sg13cmos5l_decap_8
XFILLER_56_486 VDD VSS sg13cmos5l_fill_1
XFILLER_71_423 VDD VSS sg13cmos5l_decap_8
XFILLER_45_78 VDD VSS sg13cmos5l_fill_2
XFILLER_40_865 VDD VSS sg13cmos5l_decap_8
XFILLER_61_44 VDD VSS sg13cmos5l_decap_8
Xinput840 _4494_/A quant_cfg[14] VDD VSS sg13cmos5l_buf_1
XFILLER_86_41 VDD VSS sg13cmos5l_fill_1
Xinput851 _7716_/D quant_cfg[25] VDD VSS sg13cmos5l_buf_1
XFILLER_47_453 VDD VSS sg13cmos5l_decap_8
XFILLER_74_283 VDD VSS sg13cmos5l_decap_4
X_4620_ _4621_/B _4738_/A1 _4303_/A _4620_/B1 _4800_/B2 VDD VSS sg13cmos5l_a22oi_1
XFILLER_89_4 VDD VSS sg13cmos5l_fill_1
X_4551_ _4606_/B _4551_/A VDD VSS sg13cmos5l_inv_1
X_7270_ _7557_/B _7302_/A1 _7267_/Y _7269_/X VDD VSS sg13cmos5l_o21ai_1
X_4482_ _4544_/A _4482_/A _4482_/B VDD VSS sg13cmos5l_nor2_1
X_6221_ _6221_/Y _6223_/A _6221_/B VDD VSS sg13cmos5l_nand2_1
X_6152_ _6152_/Y _6152_/A _6152_/B VDD VSS sg13cmos5l_nand2_1
XFILLER_58_707 VDD VSS sg13cmos5l_fill_2
X_5103_ _5104_/A _5103_/A VDD VSS sg13cmos5l_inv_1
X_6083_ _6117_/B _6083_/A VDD VSS sg13cmos5l_inv_1
XFILLER_66_740 VDD VSS sg13cmos5l_fill_2
X_5034_ _5036_/A _5040_/B _5040_/A VDD VSS sg13cmos5l_xor2_1
XFILLER_85_548 VDD VSS sg13cmos5l_decap_8
XFILLER_65_250 VDD VSS sg13cmos5l_decap_8
XFILLER_66_773 VDD VSS sg13cmos5l_decap_4
XFILLER_81_721 VDD VSS sg13cmos5l_decap_8
X_6985_ _6986_/B _6988_/C _6988_/A VDD VSS sg13cmos5l_nand2_2
XFILLER_80_231 VDD VSS sg13cmos5l_fill_1
X_5936_ _5971_/A _5936_/A _5936_/B _5936_/C VDD VSS sg13cmos5l_nand3_1
XFILLER_81_798 VDD VSS sg13cmos5l_decap_8
X_7606_ _7607_/B _7604_/Y _7606_/B VDD VSS sg13cmos5l_nand2b_1
X_5867_ _5868_/B _6058_/B1 _5981_/A2 _6026_/B1 _5981_/B2 VDD VSS sg13cmos5l_a22oi_1
X_5798_ _5852_/A _5767_/B _5767_/A _5797_/X VDD VSS sg13cmos5l_a21oi_1
X_4818_ _4818_/Y _4818_/A _4818_/B VDD VSS sg13cmos5l_nor2_1
X_7537_ _7538_/B _7537_/A _7537_/B VDD VSS sg13cmos5l_nand2_1
X_4749_ _4758_/A _5060_/A _4749_/B VDD VSS sg13cmos5l_xnor2_1
X_7468_ _7475_/B _7598_/B _7597_/A VDD VSS sg13cmos5l_and2_1
X_6419_ _6420_/A _6490_/A _6698_/B VDD VSS sg13cmos5l_nor2_1
X_7399_ _7399_/Y _7399_/A VDD VSS sg13cmos5l_inv_1
XFILLER_88_364 VDD VSS sg13cmos5l_fill_2
XFILLER_57_751 VDD VSS sg13cmos5l_decap_4
XFILLER_60_916 VDD VSS sg13cmos5l_fill_2
XFILLER_72_43 VDD VSS sg13cmos5l_fill_1
Xclkbuf_1_0__f_clk_i clkbuf_1_0__f_clk_i/X clkbuf_0_clk_i/X VDD VSS sg13cmos5l_buf_16
XFILLER_71_297 VDD VSS sg13cmos5l_fill_2
XFILLER_72_76 VDD VSS sg13cmos5l_fill_1
XFILLER_67_526 VDD VSS sg13cmos5l_fill_1
XFILLER_63_721 VDD VSS sg13cmos5l_fill_1
Xplace710 _6901_/A _6916_/B VDD VSS sg13cmos5l_buf_1
Xplace721 _6210_/A _6205_/A VDD VSS sg13cmos5l_buf_1
Xplace732 _5757_/A _5810_/B VDD VSS sg13cmos5l_buf_1
XFILLER_51_916 VDD VSS sg13cmos5l_fill_2
Xplace743 _3964_/A _3972_/A VDD VSS sg13cmos5l_buf_1
Xplace754 place754/X place754/A VDD VSS sg13cmos5l_buf_1
X_6770_ _6770_/Y _6769_/Y _6770_/B VDD VSS sg13cmos5l_nand2b_1
X_3982_ _3983_/B _3965_/B _4175_/A2 _3999_/B _4531_/B2 VDD VSS sg13cmos5l_a22oi_1
X_5721_ _5776_/A _5721_/A _5721_/B VDD VSS sg13cmos5l_xor2_1
X_5652_ _5723_/A _5652_/A _5722_/A VDD VSS sg13cmos5l_xor2_1
X_5583_ _5710_/B _5460_/A _6136_/B _5520_/Y VDD VSS sg13cmos5l_a21oi_1
X_4603_ _4604_/B _4662_/B _4662_/A VDD VSS sg13cmos5l_xor2_1
X_4534_ _4598_/A _4534_/A _4534_/B VDD VSS sg13cmos5l_xor2_1
Xrebuffer2002 _4079_/B rebuffer2003/X VDD VSS sg13cmos5l_buf_1
Xrebuffer2013 _5888_/A1 _5889_/A VDD VSS sg13cmos5l_buf_1
Xrebuffer1301 rebuffer1301/X rebuffer1302/X VDD VSS sg13cmos5l_buf_1
Xrebuffer2035 _7210_/A _6752_/A VDD VSS sg13cmos5l_buf_1
Xrebuffer2046 _6764_/B _6600_/A VDD VSS sg13cmos5l_buf_1
X_7253_ _7253_/Y _7050_/Y _7233_/B _7182_/A VDD VSS sg13cmos5l_a21oi_1
X_4465_ _4469_/B _4481_/A _4480_/A VDD VSS sg13cmos5l_xnor2_1
Xrebuffer2057 _6837_/A _6497_/A VDD VSS sg13cmos5l_buf_1
Xrebuffer1334 _6852_/A1 _6436_/A VDD VSS sg13cmos5l_buf_1
Xrebuffer1323 _7465_/A _7598_/A VDD VSS sg13cmos5l_buf_1
Xrebuffer1312 rebuffer1312/X rebuffer1313/X VDD VSS sg13cmos5l_buf_1
X_7184_ _7184_/Y _7184_/A _7184_/B VDD VSS sg13cmos5l_nand2_1
X_6204_ _6204_/Y _6204_/A VDD VSS sg13cmos5l_inv_1
X_4396_ _4456_/A _4396_/A _4396_/B VDD VSS sg13cmos5l_xor2_1
XFILLER_58_515 VDD VSS sg13cmos5l_fill_1
Xrebuffer1378 rebuffer1378/X rebuffer1379/X VDD VSS sg13cmos5l_buf_1
Xrebuffer1367 rebuffer1367/X rebuffer1368/X VDD VSS sg13cmos5l_buf_1
Xrebuffer1356 rebuffer1356/X rebuffer1357/X VDD VSS sg13cmos5l_buf_1
Xrebuffer1345 rebuffer1345/X rebuffer1346/X VDD VSS sg13cmos5l_buf_1
X_6135_ _6149_/B _6135_/A _6135_/B VDD VSS sg13cmos5l_nand2_1
Xrebuffer1389 _7655_/A1 _7177_/A VDD VSS sg13cmos5l_buf_1
X_6066_ _6070_/A _6093_/B _6093_/A VDD VSS sg13cmos5l_xor2_1
XFILLER_86_857 VDD VSS sg13cmos5l_decap_8
XFILLER_45_209 VDD VSS sg13cmos5l_decap_8
XFILLER_73_507 VDD VSS sg13cmos5l_decap_8
X_5017_ _5018_/B _4888_/A _3951_/A _4825_/A _5017_/B2 VDD VSS sg13cmos5l_a22oi_1
XFILLER_38_261 VDD VSS sg13cmos5l_fill_1
XFILLER_38_272 VDD VSS sg13cmos5l_decap_4
XFILLER_66_570 VDD VSS sg13cmos5l_decap_8
XFILLER_73_529 VDD VSS sg13cmos5l_decap_8
XFILLER_85_389 VDD VSS sg13cmos5l_decap_8
XFILLER_38_294 VDD VSS sg13cmos5l_decap_4
XFILLER_54_754 VDD VSS sg13cmos5l_fill_1
XFILLER_66_592 VDD VSS sg13cmos5l_fill_2
XFILLER_54_776 VDD VSS sg13cmos5l_decap_8
XFILLER_54_787 VDD VSS sg13cmos5l_decap_8
XFILLER_41_448 VDD VSS sg13cmos5l_decap_4
X_6968_ _6968_/X _6968_/A _6968_/B VDD VSS sg13cmos5l_and2_1
XFILLER_81_595 VDD VSS sg13cmos5l_decap_8
X_6899_ _6991_/B _6899_/A _6899_/B _7046_/B VDD VSS sg13cmos5l_nand3_1
X_5919_ _5962_/B _5878_/B _5878_/A _5918_/Y VDD VSS sg13cmos5l_a21oi_1
XFILLER_42_46 VDD VSS sg13cmos5l_decap_8
XFILLER_3_18 VDD VSS sg13cmos5l_fill_2
XFILLER_77_802 VDD VSS sg13cmos5l_decap_8
XFILLER_67_54 VDD VSS sg13cmos5l_fill_1
Xrebuffer1890 _5846_/A rebuffer1907/X VDD VSS sg13cmos5l_buf_1
XFILLER_88_172 VDD VSS sg13cmos5l_decap_8
XFILLER_76_334 VDD VSS sg13cmos5l_fill_1
XFILLER_77_879 VDD VSS sg13cmos5l_decap_8
XFILLER_44_253 VDD VSS sg13cmos5l_fill_2
XFILLER_60_735 VDD VSS sg13cmos5l_decap_8
XFILLER_72_584 VDD VSS sg13cmos5l_decap_4
XFILLER_72_595 VDD VSS sg13cmos5l_decap_8
XFILLER_60_768 VDD VSS sg13cmos5l_decap_8
XFILLER_80_8 VDD VSS sg13cmos5l_fill_1
X_4250_ _4345_/A _4250_/A _4250_/B VDD VSS sg13cmos5l_nand2_1
XFILLER_68_824 VDD VSS sg13cmos5l_decap_8
X_4181_ _4181_/Y _4181_/A VDD VSS sg13cmos5l_inv_1
XFILLER_79_172 VDD VSS sg13cmos5l_decap_4
XFILLER_55_507 VDD VSS sg13cmos5l_fill_2
XFILLER_83_838 VDD VSS sg13cmos5l_decap_8
XFILLER_82_348 VDD VSS sg13cmos5l_decap_4
XFILLER_63_562 VDD VSS sg13cmos5l_fill_1
Xplace540 _7327_/A _6334_/A VDD VSS sg13cmos5l_buf_1
X_6822_ _6822_/X _6822_/A _6822_/B VDD VSS sg13cmos5l_xor2_1
XFILLER_63_595 VDD VSS sg13cmos5l_decap_8
Xplace551 _5871_/A2 _4158_/Y VDD VSS sg13cmos5l_buf_1
Xplace562 _5140_/B2 _4642_/B2 VDD VSS sg13cmos5l_buf_1
Xplace573 _4175_/A2 _3948_/Y VDD VSS sg13cmos5l_buf_1
Xplace584 _7078_/B _7072_/B VDD VSS sg13cmos5l_buf_1
Xplace595 _7162_/B _7187_/A VDD VSS sg13cmos5l_buf_1
X_6753_ _6753_/Y _6753_/A _6753_/B VDD VSS sg13cmos5l_xnor2_1
X_3965_ _3966_/C _4525_/B _3965_/B VDD VSS sg13cmos5l_nand2_1
XFILLER_50_278 VDD VSS sg13cmos5l_decap_4
X_6684_ _6687_/B _6684_/A _7704_/Q _6684_/C VDD VSS sg13cmos5l_nand3_1
X_5704_ _5719_/A _5704_/A _5704_/B VDD VSS sg13cmos5l_xor2_1
X_5635_ _5690_/A _5870_/A _5635_/B VDD VSS sg13cmos5l_xnor2_1
X_5566_ _5566_/Y _5566_/A _5566_/B VDD VSS sg13cmos5l_nand2_1
Xoutput930 bank_B_rdata[7] _6227_/B VDD VSS sg13cmos5l_buf_1
X_7305_ _7305_/Y _7557_/B _7303_/B _7557_/A VDD VSS sg13cmos5l_a21oi_1
X_5497_ _5497_/X _5497_/A _5497_/B VDD VSS sg13cmos5l_and2_1
X_4517_ _4599_/B _4517_/A _4517_/B VDD VSS sg13cmos5l_xor2_1
X_7236_ _7376_/B _7235_/B _7031_/Y _7235_/Y VDD VSS sg13cmos5l_o21ai_1
X_4448_ _4448_/Y _4448_/A _4448_/B VDD VSS sg13cmos5l_nor2_1
XFILLER_59_835 VDD VSS sg13cmos5l_decap_8
X_7167_ _7167_/Y _7167_/A _7167_/B VDD VSS sg13cmos5l_nand2_1
X_4379_ _4426_/B _4692_/A _4379_/B VDD VSS sg13cmos5l_xnor2_1
X_6118_ _6119_/B _6175_/B _6117_/B _6117_/Y VDD VSS sg13cmos5l_o21ai_1
XFILLER_86_654 VDD VSS sg13cmos5l_decap_8
XFILLER_37_57 VDD VSS sg13cmos5l_decap_4
X_6049_ _6049_/X _6049_/A _6049_/B VDD VSS sg13cmos5l_and2_1
XFILLER_37_79 VDD VSS sg13cmos5l_decap_4
XFILLER_54_551 VDD VSS sg13cmos5l_decap_8
XFILLER_82_860 VDD VSS sg13cmos5l_decap_8
XFILLER_41_278 VDD VSS sg13cmos5l_fill_2
XFILLER_78_31 VDD VSS sg13cmos5l_decap_8
XFILLER_68_109 VDD VSS sg13cmos5l_fill_1
XFILLER_78_64 VDD VSS sg13cmos5l_decap_8
XFILLER_77_621 VDD VSS sg13cmos5l_decap_8
XFILLER_49_334 VDD VSS sg13cmos5l_fill_2
XFILLER_49_345 VDD VSS sg13cmos5l_fill_2
XFILLER_76_120 VDD VSS sg13cmos5l_decap_8
XFILLER_80_808 VDD VSS sg13cmos5l_decap_8
XFILLER_45_540 VDD VSS sg13cmos5l_fill_2
XFILLER_60_532 VDD VSS sg13cmos5l_fill_2
XFILLER_60_565 VDD VSS sg13cmos5l_decap_8
X_5420_ _5485_/B _5420_/A _5420_/B VDD VSS sg13cmos5l_xnor2_1
X_5351_ _5351_/X _5351_/A _5351_/B VDD VSS sg13cmos5l_and2_1
X_5282_ _5283_/B _5318_/A _5282_/B VDD VSS sg13cmos5l_xnor2_1
X_4233_ _4350_/A _4234_/A _4233_/B _4233_/C VDD VSS sg13cmos5l_nor3_1
XFILLER_114_18 VDD VSS sg13cmos5l_fill_2
X_4164_ _4180_/A _4194_/A _4194_/B VDD VSS sg13cmos5l_xor2_1
XFILLER_67_164 VDD VSS sg13cmos5l_decap_8
X_4095_ _4095_/Y _4095_/A _4064_/A VDD VSS sg13cmos5l_nor2b_1
XFILLER_82_101 VDD VSS sg13cmos5l_fill_1
XFILLER_83_635 VDD VSS sg13cmos5l_decap_8
X_6805_ _6805_/Y _6805_/A _6805_/B VDD VSS sg13cmos5l_xnor2_1
X_3948_ _3948_/Y _5706_/B _3948_/B VDD VSS sg13cmos5l_nor2_1
X_6667_ _6668_/A _6676_/B _6676_/A VDD VSS sg13cmos5l_nor2_1
X_6598_ _6601_/B _6598_/A _7694_/Q _6598_/C VDD VSS sg13cmos5l_nand3_1
X_5618_ _5674_/A _5618_/A _5618_/B _5618_/C VDD VSS sg13cmos5l_nand3_1
X_5549_ _5550_/B _5480_/B _5788_/A _5548_/Y VDD VSS sg13cmos5l_a21oi_1
Xbank_A_sram.gen_ihp_256x32.u_sram_256x32_1175 bank_A_sram.gen_ihp_256x32.u_sram_256x32/A_BM[0]
+ VDD VSS sg13cmos5l_tiehi
Xbank_A_sram.gen_ihp_256x32.u_sram_256x32_1186 bank_A_sram.gen_ihp_256x32.u_sram_256x32/A_BM[11]
+ VDD VSS sg13cmos5l_tiehi
XFILLER_59_610 VDD VSS sg13cmos5l_fill_2
XFILLER_59_621 VDD VSS sg13cmos5l_fill_1
Xbank_A_sram.gen_ihp_256x32.u_sram_256x32_1197 bank_A_sram.gen_ihp_256x32.u_sram_256x32/A_BM[22]
+ VDD VSS sg13cmos5l_tiehi
X_7219_ _7219_/Y _7219_/A _7235_/B VDD VSS sg13cmos5l_nand2_1
XFILLER_58_142 VDD VSS sg13cmos5l_fill_1
XFILLER_59_643 VDD VSS sg13cmos5l_fill_2
XFILLER_47_816 VDD VSS sg13cmos5l_decap_8
Xbank_B_sram.gen_ihp_256x32.u_sram_256x32_1140 bank_B_sram.gen_ihp_256x32.u_sram_256x32_1140/L_LO
+ VDD VSS sg13cmos5l_tielo
XFILLER_46_337 VDD VSS sg13cmos5l_decap_8
XFILLER_73_112 VDD VSS sg13cmos5l_fill_1
Xbank_B_sram.gen_ihp_256x32.u_sram_256x32_1151 bank_B_sram.gen_ihp_256x32.u_sram_256x32_1151/L_LO
+ VDD VSS sg13cmos5l_tielo
Xbank_B_sram.gen_ihp_256x32.u_sram_256x32_1162 bank_B_sram.gen_ihp_256x32.u_sram_256x32_1162/L_LO
+ VDD VSS sg13cmos5l_tielo
Xbank_B_sram.gen_ihp_256x32.u_sram_256x32_1173 bank_B_sram.gen_ihp_256x32.u_sram_256x32_1173/L_LO
+ VDD VSS sg13cmos5l_tielo
XFILLER_55_860 VDD VSS sg13cmos5l_decap_8
XFILLER_61_307 VDD VSS sg13cmos5l_fill_2
XFILLER_64_33 VDD VSS sg13cmos5l_fill_2
XFILLER_64_44 VDD VSS sg13cmos5l_decap_8
XFILLER_74_679 VDD VSS sg13cmos5l_decap_8
XFILLER_54_370 VDD VSS sg13cmos5l_fill_1
XFILLER_42_543 VDD VSS sg13cmos5l_fill_1
XFILLER_42_576 VDD VSS sg13cmos5l_fill_1
XFILLER_42_587 VDD VSS sg13cmos5l_decap_8
XFILLER_70_896 VDD VSS sg13cmos5l_decap_8
XFILLER_80_21 VDD VSS sg13cmos5l_fill_1
XFILLER_49_120 VDD VSS sg13cmos5l_decap_8
XFILLER_37_304 VDD VSS sg13cmos5l_decap_4
XFILLER_38_849 VDD VSS sg13cmos5l_decap_8
XFILLER_65_657 VDD VSS sg13cmos5l_decap_8
XFILLER_52_307 VDD VSS sg13cmos5l_fill_1
XFILLER_64_167 VDD VSS sg13cmos5l_fill_2
XFILLER_61_830 VDD VSS sg13cmos5l_decap_8
X_4920_ _4985_/S _4986_/B1 _5050_/A2 _4920_/B1 _4920_/B2 VDD VSS sg13cmos5l_a22oi_1
XFILLER_80_649 VDD VSS sg13cmos5l_decap_8
X_4851_ _4853_/A _4851_/A VDD VSS sg13cmos5l_inv_1
X_7570_ _7571_/B _7570_/A _7570_/B VDD VSS sg13cmos5l_nand2_1
X_4782_ _4791_/A _4794_/A _4782_/B VDD VSS sg13cmos5l_xnor2_1
X_6521_ _6883_/A _7685_/Q _6521_/B VDD VSS sg13cmos5l_xnor2_1
X_6452_ _6848_/A _6452_/A _6454_/B VDD VSS sg13cmos5l_nor2b_1
X_5403_ _5404_/B _5438_/A _5403_/B VDD VSS sg13cmos5l_xnor2_1
X_6383_ _6385_/A _6383_/A _6383_/B VDD VSS sg13cmos5l_nand2_2
X_5334_ _5335_/C _5334_/A VDD VSS sg13cmos5l_inv_1
X_5265_ _5283_/A _5265_/A _5265_/B VDD VSS sg13cmos5l_xor2_1
XFILLER_87_215 VDD VSS sg13cmos5l_fill_1
X_7004_ _7004_/Y _7004_/A _7004_/B VDD VSS sg13cmos5l_nor2_1
X_5196_ _5214_/A _5196_/A _5196_/B VDD VSS sg13cmos5l_xor2_1
XFILLER_18_15 VDD VSS sg13cmos5l_decap_4
X_4147_ _4149_/A _4147_/A VDD VSS sg13cmos5l_inv_1
X_4078_ _4110_/B _4207_/A _4078_/B VDD VSS sg13cmos5l_xnor2_1
XFILLER_37_882 VDD VSS sg13cmos5l_decap_4
XFILLER_55_178 VDD VSS sg13cmos5l_decap_8
XFILLER_71_649 VDD VSS sg13cmos5l_fill_2
XFILLER_52_852 VDD VSS sg13cmos5l_decap_8
X_7699_ _7699_/Q clkload7/A _7699_/D place751/X VDD VSS sg13cmos5l_dfrbpq_1
Xclkload2 clkload2/Y clkload2/A VDD VSS sg13cmos5l_inv_1
X_6719_ _7105_/A _6990_/A _7046_/B _6990_/C VDD VSS sg13cmos5l_nand3_1
XFILLER_119_4 VDD VSS sg13cmos5l_decap_8
XFILLER_50_79 VDD VSS sg13cmos5l_fill_2
XFILLER_1_4 VDD VSS sg13cmos5l_decap_8
XFILLER_47_657 VDD VSS sg13cmos5l_decap_8
XFILLER_61_104 VDD VSS sg13cmos5l_fill_2
XFILLER_62_627 VDD VSS sg13cmos5l_decap_8
XFILLER_62_649 VDD VSS sg13cmos5l_decap_4
XFILLER_43_885 VDD VSS sg13cmos5l_decap_8
XFILLER_42_384 VDD VSS sg13cmos5l_fill_2
XFILLER_69_215 VDD VSS sg13cmos5l_decap_8
XFILLER_69_237 VDD VSS sg13cmos5l_decap_4
X_5050_ _5115_/S _5117_/B1 _5050_/A2 _5050_/B1 _5370_/B2 VDD VSS sg13cmos5l_a22oi_1
XFILLER_38_635 VDD VSS sg13cmos5l_fill_2
XFILLER_78_793 VDD VSS sg13cmos5l_decap_8
XFILLER_53_605 VDD VSS sg13cmos5l_decap_8
XFILLER_81_903 VDD VSS sg13cmos5l_decap_8
XFILLER_111_19 VDD VSS sg13cmos5l_fill_2
XFILLER_52_115 VDD VSS sg13cmos5l_fill_1
XFILLER_65_498 VDD VSS sg13cmos5l_fill_2
X_5952_ _5954_/A _5984_/S _5952_/B VDD VSS sg13cmos5l_xnor2_1
X_4903_ _4904_/B _4963_/B _4963_/A VDD VSS sg13cmos5l_xor2_1
X_5883_ _5884_/B _5928_/B _5928_/A VDD VSS sg13cmos5l_xnor2_1
X_7622_ _7623_/D _7573_/A _7622_/B VDD VSS sg13cmos5l_nand2b_1
X_4834_ _4901_/B _4834_/A _4834_/B VDD VSS sg13cmos5l_xor2_1
X_7553_ _7613_/C _7553_/A VDD VSS sg13cmos5l_inv_1
X_4765_ _4768_/A _5012_/A1 _4766_/A _5012_/B1 VDD VSS sg13cmos5l_a21oi_1
X_6504_ _6836_/B _6504_/A _6504_/B VDD VSS sg13cmos5l_nand2_1
X_7484_ _7485_/A _7484_/A _7484_/B _7484_/C VDD VSS sg13cmos5l_nand3_1
X_4696_ _4746_/A _4653_/B _4653_/A _4695_/Y VDD VSS sg13cmos5l_a21oi_1
X_6435_ _6820_/B _6435_/A _6435_/B VDD VSS sg13cmos5l_nand2_1
X_6366_ _6368_/A _6621_/A _6654_/B VDD VSS sg13cmos5l_nand2_1
X_5317_ _5407_/B _5317_/A _5317_/B VDD VSS sg13cmos5l_xor2_1
X_6297_ _6298_/B _6296_/Y _6294_/Y _6328_/C VDD VSS sg13cmos5l_o21ai_1
XFILLER_88_568 VDD VSS sg13cmos5l_fill_2
XFILLER_88_546 VDD VSS sg13cmos5l_decap_4
XFILLER_69_771 VDD VSS sg13cmos5l_fill_2
XFILLER_75_218 VDD VSS sg13cmos5l_decap_4
X_5248_ _5305_/A _5307_/A _5307_/B VDD VSS sg13cmos5l_xor2_1
XFILLER_68_281 VDD VSS sg13cmos5l_decap_8
X_5179_ _5180_/B _5370_/B1 _5179_/A2 _5310_/B1 _5246_/B2 VDD VSS sg13cmos5l_a22oi_1
XFILLER_84_730 VDD VSS sg13cmos5l_decap_8
XFILLER_72_914 VDD VSS sg13cmos5l_decap_4
XFILLER_71_479 VDD VSS sg13cmos5l_decap_8
XFILLER_40_844 VDD VSS sg13cmos5l_decap_8
XFILLER_52_693 VDD VSS sg13cmos5l_fill_1
XFILLER_6_18 VDD VSS sg13cmos5l_fill_2
XFILLER_79_568 VDD VSS sg13cmos5l_fill_2
Xinput830 input830/X bank_B_wdata[4] VDD VSS sg13cmos5l_buf_1
XFILLER_47_432 VDD VSS sg13cmos5l_decap_8
Xinput841 _4494_/B quant_cfg[15] VDD VSS sg13cmos5l_buf_1
Xinput852 _7717_/D quant_cfg[26] VDD VSS sg13cmos5l_buf_1
XFILLER_75_741 VDD VSS sg13cmos5l_fill_1
XFILLER_63_903 VDD VSS sg13cmos5l_decap_8
XFILLER_75_752 VDD VSS sg13cmos5l_fill_1
XFILLER_62_446 VDD VSS sg13cmos5l_decap_4
X_4550_ _4606_/A _4550_/A VDD VSS sg13cmos5l_inv_1
X_4481_ _4482_/B _4481_/A VDD VSS sg13cmos5l_inv_1
X_6220_ _6220_/Y _6210_/A _6195_/Y _6219_/Y VDD VSS sg13cmos5l_o21ai_1
X_6151_ _6170_/B _6175_/B _6151_/B VDD VSS sg13cmos5l_xnor2_1
X_5102_ _5107_/A _5102_/A VDD VSS sg13cmos5l_inv_1
XFILLER_25_0 VDD VSS sg13cmos5l_fill_2
XFILLER_39_911 VDD VSS sg13cmos5l_decap_8
XFILLER_57_207 VDD VSS sg13cmos5l_decap_4
X_6082_ _6083_/A _6082_/A1 _6082_/A2 _6082_/B1 _6082_/B2 VDD VSS sg13cmos5l_a22oi_1
XFILLER_57_218 VDD VSS sg13cmos5l_decap_4
X_5033_ _5040_/A _5041_/B _5041_/A VDD VSS sg13cmos5l_xor2_1
XFILLER_38_432 VDD VSS sg13cmos5l_fill_1
XFILLER_66_752 VDD VSS sg13cmos5l_decap_8
XFILLER_53_413 VDD VSS sg13cmos5l_fill_2
XFILLER_81_700 VDD VSS sg13cmos5l_decap_8
X_6984_ _6988_/C _6954_/Y _7299_/A1 _6983_/Y VDD VSS sg13cmos5l_o21ai_1
XFILLER_80_210 VDD VSS sg13cmos5l_fill_1
X_5935_ _7697_/D _5935_/A _5935_/B VDD VSS sg13cmos5l_xnor2_1
XFILLER_81_777 VDD VSS sg13cmos5l_decap_8
XFILLER_80_265 VDD VSS sg13cmos5l_decap_4
X_5866_ _5918_/A _5866_/A _5866_/B VDD VSS sg13cmos5l_xnor2_1
X_7605_ _7606_/B _7605_/A _7605_/B _7605_/C VDD VSS sg13cmos5l_nand3_1
X_4817_ _4834_/A _4817_/A _4817_/B VDD VSS sg13cmos5l_xor2_1
X_5797_ _5797_/X _5797_/A _5797_/B VDD VSS sg13cmos5l_and2_1
X_7536_ _7538_/A _7536_/A _7536_/B VDD VSS sg13cmos5l_nand2_1
X_4748_ _4749_/B _4748_/A1 _4930_/A2 _4986_/B1 _5188_/B2 VDD VSS sg13cmos5l_a22oi_1
X_7467_ _7597_/A _7464_/A _7603_/A VDD VSS sg13cmos5l_nand2b_1
X_4679_ _4682_/A _4736_/S _4679_/B VDD VSS sg13cmos5l_xnor2_1
X_6418_ _6490_/A _6418_/A VDD VSS sg13cmos5l_inv_1
X_6349_ _6350_/B _6349_/A _7667_/Q VDD VSS sg13cmos5l_xnor2_1
XFILLER_49_708 VDD VSS sg13cmos5l_decap_8
XFILLER_56_23 VDD VSS sg13cmos5l_fill_1
XFILLER_88_398 VDD VSS sg13cmos5l_decap_4
XFILLER_56_251 VDD VSS sg13cmos5l_decap_8
XFILLER_56_262 VDD VSS sg13cmos5l_fill_1
XFILLER_56_67 VDD VSS sg13cmos5l_decap_4
XFILLER_56_78 VDD VSS sg13cmos5l_decap_4
XFILLER_71_221 VDD VSS sg13cmos5l_fill_2
XFILLER_40_663 VDD VSS sg13cmos5l_decap_8
XFILLER_72_99 VDD VSS sg13cmos5l_decap_4
XFILLER_79_343 VDD VSS sg13cmos5l_fill_1
XFILLER_79_376 VDD VSS sg13cmos5l_fill_2
XFILLER_48_730 VDD VSS sg13cmos5l_decap_8
XFILLER_67_549 VDD VSS sg13cmos5l_decap_4
XFILLER_47_295 VDD VSS sg13cmos5l_fill_2
Xplace700 _7087_/A _7018_/B VDD VSS sg13cmos5l_buf_1
Xplace711 _6916_/B _6929_/B VDD VSS sg13cmos5l_buf_1
Xplace722 _6085_/A _5747_/A VDD VSS sg13cmos5l_buf_1
XFILLER_63_777 VDD VSS sg13cmos5l_fill_1
Xplace733 _5810_/B _4322_/A VDD VSS sg13cmos5l_buf_1
Xplace744 _3972_/A _3955_/A VDD VSS sg13cmos5l_buf_1
XFILLER_50_438 VDD VSS sg13cmos5l_fill_2
X_5720_ _5721_/B _5742_/A _5742_/B VDD VSS sg13cmos5l_xnor2_1
X_5651_ _5722_/A _5592_/B _5592_/A _5650_/Y VDD VSS sg13cmos5l_a21oi_1
X_5582_ _5590_/A _5757_/A _5582_/B VDD VSS sg13cmos5l_xnor2_1
X_4602_ _4662_/A _4602_/A _4602_/B VDD VSS sg13cmos5l_xor2_1
X_7321_ _7323_/A _7289_/A _7318_/Y _7320_/Y VDD VSS sg13cmos5l_o21ai_1
X_4533_ _4534_/B _4581_/A _4581_/B VDD VSS sg13cmos5l_xor2_1
XFILLER_117_18 VDD VSS sg13cmos5l_fill_2
Xrebuffer2003 rebuffer2003/X _4062_/A VDD VSS sg13cmos5l_buf_1
X_7252_ _7252_/Y _7299_/A1 _7247_/Y _7251_/Y VDD VSS sg13cmos5l_o21ai_1
Xrebuffer1302 rebuffer1302/X rebuffer1303/X VDD VSS sg13cmos5l_buf_1
Xrebuffer2014 _6157_/B _6156_/X VDD VSS sg13cmos5l_buf_1
Xrebuffer2036 _7494_/A1 _7453_/A VDD VSS sg13cmos5l_buf_1
X_6203_ _6203_/Y _6209_/A1 _6201_/Y _6202_/Y VDD VSS sg13cmos5l_a21oi_1
X_4464_ _4480_/A _4483_/A _4464_/B VDD VSS sg13cmos5l_xnor2_1
Xrebuffer2047 _6791_/A _6330_/B VDD VSS sg13cmos5l_buf_1
Xrebuffer2058 _6790_/B _6340_/A VDD VSS sg13cmos5l_buf_1
Xrebuffer1335 rebuffer1335/X rebuffer1336/X VDD VSS sg13cmos5l_buf_1
Xrebuffer1324 _6802_/B _6275_/B VDD VSS sg13cmos5l_buf_1
Xrebuffer1313 rebuffer1313/X rebuffer1314/X VDD VSS sg13cmos5l_buf_1
X_7183_ _7356_/A _7183_/A _7234_/B VDD VSS sg13cmos5l_nand2_1
X_4395_ _4396_/B _4440_/A _4440_/B VDD VSS sg13cmos5l_xor2_1
Xrebuffer1368 rebuffer1368/X rebuffer1369/X VDD VSS sg13cmos5l_buf_1
Xrebuffer1357 rebuffer1357/X rebuffer1358/X VDD VSS sg13cmos5l_buf_1
Xrebuffer1346 rebuffer1346/X rebuffer1347/X VDD VSS sg13cmos5l_buf_1
X_6134_ _7703_/D _6134_/A _6134_/B VDD VSS sg13cmos5l_xor2_1
Xrebuffer1379 rebuffer1379/X rebuffer1380/X VDD VSS sg13cmos5l_buf_1
X_6065_ _6093_/A _6094_/B _6094_/A VDD VSS sg13cmos5l_xor2_1
XFILLER_86_836 VDD VSS sg13cmos5l_decap_8
X_5016_ _5070_/A _4947_/B _4946_/A _5015_/Y VDD VSS sg13cmos5l_a21o_1
XFILLER_39_785 VDD VSS sg13cmos5l_decap_8
X_6967_ _6967_/Y _7221_/B _6981_/A VDD VSS sg13cmos5l_nand2b_1
XFILLER_41_427 VDD VSS sg13cmos5l_decap_8
XFILLER_53_287 VDD VSS sg13cmos5l_decap_8
X_5918_ _5918_/Y _5918_/A _5918_/B VDD VSS sg13cmos5l_nor2_1
X_6898_ _6900_/B _7045_/A _7054_/B _7045_/B VDD VSS sg13cmos5l_nand3_1
X_5849_ _5851_/A _5825_/A _5849_/B VDD VSS sg13cmos5l_nand2b_1
X_7519_ _7520_/B _7519_/A _7519_/B VDD VSS sg13cmos5l_nand2_1
XFILLER_88_140 VDD VSS sg13cmos5l_fill_1
Xclkbuf_4_13_0_clk_i_regs clkload7/A clkbuf_0_clk_i_regs/X VDD VSS sg13cmos5l_buf_8
Xrebuffer1891 _4670_/B _4727_/A VDD VSS sg13cmos5l_buf_1
Xrebuffer1880 _4243_/B rebuffer1999/X VDD VSS sg13cmos5l_buf_1
XFILLER_77_858 VDD VSS sg13cmos5l_decap_8
XFILLER_85_891 VDD VSS sg13cmos5l_decap_8
XFILLER_76_379 VDD VSS sg13cmos5l_decap_4
XFILLER_45_733 VDD VSS sg13cmos5l_fill_1
XFILLER_72_530 VDD VSS sg13cmos5l_fill_1
XFILLER_83_32 VDD VSS sg13cmos5l_fill_2
XFILLER_83_54 VDD VSS sg13cmos5l_decap_8
XFILLER_44_276 VDD VSS sg13cmos5l_decap_8
XFILLER_45_799 VDD VSS sg13cmos5l_decap_8
XFILLER_60_747 VDD VSS sg13cmos5l_decap_8
XFILLER_40_493 VDD VSS sg13cmos5l_decap_4
X_4180_ _4184_/B _4180_/A _4180_/B VDD VSS sg13cmos5l_xor2_1
XFILLER_67_324 VDD VSS sg13cmos5l_fill_2
XFILLER_67_346 VDD VSS sg13cmos5l_decap_8
XFILLER_83_817 VDD VSS sg13cmos5l_decap_8
XFILLER_55_519 VDD VSS sg13cmos5l_fill_1
XFILLER_82_338 VDD VSS sg13cmos5l_fill_2
XFILLER_51_703 VDD VSS sg13cmos5l_fill_1
XFILLER_51_714 VDD VSS sg13cmos5l_decap_8
XFILLER_63_541 VDD VSS sg13cmos5l_fill_1
Xplace530 _6265_/A place530/A VDD VSS sg13cmos5l_buf_8
X_6821_ _6822_/B _6821_/A _6821_/B VDD VSS sg13cmos5l_nand2_1
XFILLER_50_224 VDD VSS sg13cmos5l_fill_1
XFILLER_51_747 VDD VSS sg13cmos5l_fill_2
Xplace541 _6111_/A _5811_/A VDD VSS sg13cmos5l_buf_1
Xplace552 _4878_/A2 _4378_/A2 VDD VSS sg13cmos5l_buf_1
Xplace563 _4642_/B2 _4271_/B2 VDD VSS sg13cmos5l_buf_1
Xplace574 _7557_/A _7331_/B VDD VSS sg13cmos5l_buf_1
Xplace585 _7072_/B _6261_/B VDD VSS sg13cmos5l_buf_1
Xplace596 _7187_/A _6979_/B VDD VSS sg13cmos5l_buf_1
X_6752_ _7311_/A _6752_/A _7109_/A _7210_/C VDD VSS sg13cmos5l_nand3_1
X_3964_ _3966_/B _3964_/A _5335_/A _3964_/C VDD VSS sg13cmos5l_nand3_1
X_6683_ _6685_/A _6684_/A _6684_/C _7704_/Q VDD VSS sg13cmos5l_a21oi_1
X_5703_ _5704_/B _5749_/A _5749_/B VDD VSS sg13cmos5l_xor2_1
X_5634_ _5635_/B _6058_/B1 _5869_/A2 _6026_/B1 _5869_/B2 VDD VSS sg13cmos5l_a22oi_1
X_7304_ _7310_/A _7304_/A _7304_/B _7559_/A VDD VSS sg13cmos5l_nand3_1
X_5565_ _5565_/Y _5565_/A VDD VSS sg13cmos5l_inv_1
Xoutput920 bank_B_rdata[27] wire966/X VDD VSS sg13cmos5l_buf_1
X_5496_ _5499_/A _5556_/S _5496_/B VDD VSS sg13cmos5l_xnor2_1
X_4516_ _4517_/B _4568_/A _4568_/B VDD VSS sg13cmos5l_xor2_1
Xoutput931 bank_B_rdata[8] output931/A VDD VSS sg13cmos5l_buf_1
X_7235_ _7235_/Y _7235_/A _7235_/B VDD VSS sg13cmos5l_nand2_1
X_4447_ _4448_/B _4447_/A _4447_/B _4447_/C VDD VSS sg13cmos5l_nor3_1
XFILLER_59_814 VDD VSS sg13cmos5l_fill_1
X_7166_ _7167_/B _7166_/A _7294_/B VDD VSS sg13cmos5l_nand2_1
X_6117_ _6117_/Y _6117_/A _6117_/B VDD VSS sg13cmos5l_nand2_1
X_4378_ _4379_/B _4738_/A1 _4378_/A2 _4620_/B1 _4378_/B2 VDD VSS sg13cmos5l_a22oi_1
XFILLER_86_633 VDD VSS sg13cmos5l_decap_8
XFILLER_58_357 VDD VSS sg13cmos5l_fill_2
X_7097_ _7123_/A _7097_/A _7641_/A _7642_/B VDD VSS sg13cmos5l_nand3_1
XFILLER_58_379 VDD VSS sg13cmos5l_fill_1
X_6048_ _6100_/B _6048_/A _6039_/A VDD VSS sg13cmos5l_nor2b_1
XFILLER_66_390 VDD VSS sg13cmos5l_decap_4
XFILLER_73_349 VDD VSS sg13cmos5l_fill_2
XFILLER_85_198 VDD VSS sg13cmos5l_decap_4
XFILLER_53_35 VDD VSS sg13cmos5l_fill_2
XFILLER_54_574 VDD VSS sg13cmos5l_fill_2
XFILLER_53_57 VDD VSS sg13cmos5l_decap_8
XFILLER_49_313 VDD VSS sg13cmos5l_decap_4
XFILLER_94_20 VDD VSS sg13cmos5l_fill_1
XFILLER_77_688 VDD VSS sg13cmos5l_decap_8
XFILLER_64_349 VDD VSS sg13cmos5l_decap_8
XFILLER_60_511 VDD VSS sg13cmos5l_fill_1
XFILLER_73_894 VDD VSS sg13cmos5l_decap_8
XFILLER_64_4 VDD VSS sg13cmos5l_fill_2
X_5350_ _5364_/B _5412_/A _5350_/B VDD VSS sg13cmos5l_xnor2_1
X_5281_ _5282_/B _5281_/A _5281_/B VDD VSS sg13cmos5l_xor2_1
X_4301_ _4301_/Y _6111_/B _6110_/A VDD VSS sg13cmos5l_nor2b_1
XFILLER_88_909 VDD VSS sg13cmos5l_decap_8
X_7020_ _7020_/Y _7020_/A _7112_/B VDD VSS sg13cmos5l_nand2_1
X_4232_ _4237_/B _4250_/A _4232_/B VDD VSS sg13cmos5l_xnor2_1
XFILLER_87_419 VDD VSS sg13cmos5l_decap_8
XFILLER_67_121 VDD VSS sg13cmos5l_decap_8
XFILLER_67_132 VDD VSS sg13cmos5l_fill_2
X_4163_ _4194_/B _4266_/A _4163_/B VDD VSS sg13cmos5l_xnor2_1
X_4094_ _4097_/B _4094_/A _4110_/B VDD VSS sg13cmos5l_xor2_1
XFILLER_83_614 VDD VSS sg13cmos5l_decap_8
XFILLER_71_809 VDD VSS sg13cmos5l_decap_8
XFILLER_63_360 VDD VSS sg13cmos5l_fill_2
XFILLER_64_883 VDD VSS sg13cmos5l_decap_8
X_6804_ _6805_/B _6804_/A _6273_/Y VDD VSS sg13cmos5l_nor2b_1
XFILLER_51_599 VDD VSS sg13cmos5l_decap_8
X_6735_ _6904_/B _6735_/A _6735_/B VDD VSS sg13cmos5l_xnor2_1
X_3947_ _3948_/B _3947_/A VDD VSS sg13cmos5l_inv_1
X_6666_ _6676_/A _6681_/A _6665_/Y _6641_/C VDD VSS sg13cmos5l_o21ai_1
X_6597_ _6599_/A _6598_/A _6598_/C _7694_/Q VDD VSS sg13cmos5l_a21oi_1
X_5617_ _7691_/D _5617_/A _5617_/B VDD VSS sg13cmos5l_xnor2_1
X_5548_ _5548_/Y _5548_/A _5479_/A VDD VSS sg13cmos5l_nor2b_1
Xbank_A_sram.gen_ihp_256x32.u_sram_256x32_1176 bank_A_sram.gen_ihp_256x32.u_sram_256x32/A_BM[1]
+ VDD VSS sg13cmos5l_tiehi
Xbank_A_sram.gen_ihp_256x32.u_sram_256x32_1187 bank_A_sram.gen_ihp_256x32.u_sram_256x32/A_BM[12]
+ VDD VSS sg13cmos5l_tiehi
X_5479_ _5480_/B _5479_/A _5548_/A VDD VSS sg13cmos5l_xnor2_1
Xbank_A_sram.gen_ihp_256x32.u_sram_256x32_1198 bank_A_sram.gen_ihp_256x32.u_sram_256x32/A_BM[23]
+ VDD VSS sg13cmos5l_tiehi
X_7149_ _7650_/A _7149_/A VDD VSS sg13cmos5l_inv_1
XFILLER_46_316 VDD VSS sg13cmos5l_fill_1
XFILLER_48_68 VDD VSS sg13cmos5l_fill_1
Xbank_B_sram.gen_ihp_256x32.u_sram_256x32_1130 bank_B_sram.gen_ihp_256x32.u_sram_256x32_1130/L_LO
+ VDD VSS sg13cmos5l_tielo
XFILLER_58_187 VDD VSS sg13cmos5l_fill_2
XFILLER_73_124 VDD VSS sg13cmos5l_decap_8
XFILLER_74_636 VDD VSS sg13cmos5l_decap_4
XFILLER_74_658 VDD VSS sg13cmos5l_decap_8
Xbank_B_sram.gen_ihp_256x32.u_sram_256x32_1141 bank_B_sram.gen_ihp_256x32.u_sram_256x32_1141/L_LO
+ VDD VSS sg13cmos5l_tielo
Xbank_B_sram.gen_ihp_256x32.u_sram_256x32_1152 bank_B_sram.gen_ihp_256x32.u_sram_256x32_1152/L_LO
+ VDD VSS sg13cmos5l_tielo
Xbank_B_sram.gen_ihp_256x32.u_sram_256x32_1163 bank_B_sram.gen_ihp_256x32.u_sram_256x32_1163/L_LO
+ VDD VSS sg13cmos5l_tielo
Xbank_B_sram.gen_ihp_256x32.u_sram_256x32_1174 bank_B_sram.gen_ihp_256x32.u_sram_256x32_1174/L_LO
+ VDD VSS sg13cmos5l_tielo
XFILLER_86_496 VDD VSS sg13cmos5l_decap_8
XFILLER_42_522 VDD VSS sg13cmos5l_decap_8
XFILLER_70_875 VDD VSS sg13cmos5l_decap_8
XFILLER_80_33 VDD VSS sg13cmos5l_fill_1
XFILLER_80_66 VDD VSS sg13cmos5l_decap_4
XFILLER_38_828 VDD VSS sg13cmos5l_decap_8
XFILLER_77_463 VDD VSS sg13cmos5l_fill_2
XFILLER_77_452 VDD VSS sg13cmos5l_decap_8
XFILLER_37_338 VDD VSS sg13cmos5l_fill_1
XFILLER_49_176 VDD VSS sg13cmos5l_fill_2
XFILLER_64_124 VDD VSS sg13cmos5l_fill_1
XFILLER_80_606 VDD VSS sg13cmos5l_fill_1
XFILLER_46_883 VDD VSS sg13cmos5l_decap_8
X_4850_ _4974_/B _4850_/A _4843_/A VDD VSS sg13cmos5l_nor2b_1
XFILLER_61_886 VDD VSS sg13cmos5l_decap_8
X_6520_ _6521_/B _6534_/A _6519_/Y _6502_/C VDD VSS sg13cmos5l_o21ai_1
X_4781_ _4782_/B _4781_/A _4781_/B VDD VSS sg13cmos5l_xor2_1
XFILLER_109_19 VDD VSS sg13cmos5l_fill_2
X_6451_ _6454_/B _6451_/A _7677_/Q _6461_/C VDD VSS sg13cmos5l_nand3_1
X_6382_ _6383_/A _6382_/A _7670_/Q VDD VSS sg13cmos5l_xnor2_1
X_5402_ _5403_/B _5402_/A _5402_/B VDD VSS sg13cmos5l_xor2_1
X_5333_ _5336_/A _5517_/A _5641_/B1 _5519_/B VDD VSS sg13cmos5l_a21oi_1
XFILLER_125_18 VDD VSS sg13cmos5l_fill_2
X_5264_ _5265_/B _5314_/A _5314_/B VDD VSS sg13cmos5l_xor2_1
XFILLER_87_227 VDD VSS sg13cmos5l_fill_2
X_7003_ _7161_/A _7002_/B _7001_/Y _7002_/Y VDD VSS sg13cmos5l_o21ai_1
X_5195_ _5196_/B _5249_/A _5249_/B VDD VSS sg13cmos5l_xor2_1
X_4215_ _4225_/A _4322_/A _4215_/B VDD VSS sg13cmos5l_xnor2_1
XFILLER_87_249 VDD VSS sg13cmos5l_decap_8
X_4146_ _4234_/A _4146_/A _4146_/B VDD VSS sg13cmos5l_nand2_1
XFILLER_84_912 VDD VSS sg13cmos5l_decap_4
XFILLER_55_102 VDD VSS sg13cmos5l_fill_2
XFILLER_55_146 VDD VSS sg13cmos5l_fill_1
XFILLER_56_658 VDD VSS sg13cmos5l_fill_1
XFILLER_71_606 VDD VSS sg13cmos5l_decap_4
X_4077_ _4078_/B _3965_/B _4048_/A _4303_/B _4311_/B2 VDD VSS sg13cmos5l_a22oi_1
XFILLER_83_466 VDD VSS sg13cmos5l_decap_8
XFILLER_37_872 VDD VSS sg13cmos5l_decap_4
XFILLER_70_116 VDD VSS sg13cmos5l_fill_1
XFILLER_52_831 VDD VSS sg13cmos5l_decap_8
XFILLER_64_691 VDD VSS sg13cmos5l_fill_1
X_4979_ _4980_/B _4979_/A _4979_/B VDD VSS sg13cmos5l_nand2_1
X_7698_ _7698_/Q _7702_/CLK _7698_/D place751/X VDD VSS sg13cmos5l_dfrbpq_1
Xclkload3 clkload3/Y clkload3/A VDD VSS sg13cmos5l_inv_1
X_6718_ _6990_/C _6896_/A _6918_/B VDD VSS sg13cmos5l_nand2_1
XFILLER_59_34 VDD VSS sg13cmos5l_fill_1
XFILLER_78_227 VDD VSS sg13cmos5l_decap_8
XFILLER_59_89 VDD VSS sg13cmos5l_fill_2
XFILLER_47_614 VDD VSS sg13cmos5l_decap_8
XFILLER_59_441 VDD VSS sg13cmos5l_fill_2
XFILLER_75_912 VDD VSS sg13cmos5l_decap_4
XFILLER_74_433 VDD VSS sg13cmos5l_fill_2
XFILLER_87_794 VDD VSS sg13cmos5l_decap_8
XFILLER_75_22 VDD VSS sg13cmos5l_decap_8
XFILLER_46_135 VDD VSS sg13cmos5l_decap_8
XFILLER_75_66 VDD VSS sg13cmos5l_fill_2
XFILLER_62_617 VDD VSS sg13cmos5l_fill_1
XFILLER_43_864 VDD VSS sg13cmos5l_decap_8
XFILLER_85_709 VDD VSS sg13cmos5l_decap_8
XFILLER_66_901 VDD VSS sg13cmos5l_decap_8
X_4000_ _4010_/A _4322_/A _4000_/B VDD VSS sg13cmos5l_xnor2_1
XFILLER_78_772 VDD VSS sg13cmos5l_decap_8
XFILLER_37_102 VDD VSS sg13cmos5l_decap_8
XFILLER_38_647 VDD VSS sg13cmos5l_decap_8
XFILLER_65_422 VDD VSS sg13cmos5l_fill_1
XFILLER_65_433 VDD VSS sg13cmos5l_fill_2
XFILLER_77_282 VDD VSS sg13cmos5l_fill_2
XFILLER_65_477 VDD VSS sg13cmos5l_fill_2
X_5951_ _5952_/B _6085_/A _5951_/B VDD VSS sg13cmos5l_xnor2_1
XFILLER_46_691 VDD VSS sg13cmos5l_fill_2
XFILLER_52_149 VDD VSS sg13cmos5l_decap_8
X_4902_ _4963_/A _4902_/A _4902_/B VDD VSS sg13cmos5l_nand2_1
XFILLER_80_447 VDD VSS sg13cmos5l_fill_1
XFILLER_80_436 VDD VSS sg13cmos5l_decap_8
X_5882_ _5928_/B _5882_/A _5891_/A VDD VSS sg13cmos5l_xor2_1
X_7621_ _7622_/B _7621_/A _7621_/B _7621_/C _7621_/D VDD VSS sg13cmos5l_nor4_1
X_4833_ _4834_/B _4867_/A _4833_/B VDD VSS sg13cmos5l_xnor2_1
X_7552_ _7553_/A _7552_/A _7552_/B VDD VSS sg13cmos5l_xor2_1
X_7483_ _7485_/B _7483_/A _7483_/B VDD VSS sg13cmos5l_nand2_2
X_6503_ _6505_/B _6503_/A _6506_/B VDD VSS sg13cmos5l_nor2b_1
X_6434_ _6436_/B _7675_/Q _6434_/B VDD VSS sg13cmos5l_xnor2_1
X_4695_ _4695_/Y _4695_/A _4695_/B VDD VSS sg13cmos5l_nor2_1
X_6365_ _6654_/B _6407_/B _6533_/B _7141_/A _6517_/C VDD VSS sg13cmos5l_nor4_1
Xmax_cap974 _4171_/A wire975/X VDD VSS sg13cmos5l_buf_8
Xmax_cap985 _4156_/A1 _3975_/A VDD VSS sg13cmos5l_buf_8
X_6296_ _6296_/Y _6305_/B VDD VSS sg13cmos5l_inv_2
X_5316_ _5317_/B _5366_/A _5366_/B VDD VSS sg13cmos5l_xor2_1
XFILLER_88_514 VDD VSS sg13cmos5l_decap_8
XFILLER_29_15 VDD VSS sg13cmos5l_decap_4
X_5247_ _5307_/B _5432_/A _5247_/B VDD VSS sg13cmos5l_xnor2_1
XFILLER_68_271 VDD VSS sg13cmos5l_decap_4
X_5178_ _5243_/S _5244_/B1 _5493_/A2 _5178_/B1 _5370_/B2 VDD VSS sg13cmos5l_a22oi_1
X_4129_ _4129_/Y _4129_/A _4129_/B VDD VSS sg13cmos5l_nor2_1
XFILLER_45_25 VDD VSS sg13cmos5l_decap_4
XFILLER_84_786 VDD VSS sg13cmos5l_decap_8
XFILLER_43_138 VDD VSS sg13cmos5l_fill_1
XFILLER_71_458 VDD VSS sg13cmos5l_decap_8
XFILLER_40_823 VDD VSS sg13cmos5l_decap_8
XFILLER_61_24 VDD VSS sg13cmos5l_decap_4
XFILLER_48_912 VDD VSS sg13cmos5l_decap_4
Xinput820 input820/X bank_B_wdata[24] VDD VSS sg13cmos5l_buf_1
Xinput831 input831/X bank_B_wdata[5] VDD VSS sg13cmos5l_buf_1
XFILLER_59_260 VDD VSS sg13cmos5l_fill_2
Xinput842 _7707_/D quant_cfg[16] VDD VSS sg13cmos5l_buf_1
Xinput853 _7718_/D quant_cfg[27] VDD VSS sg13cmos5l_buf_1
XFILLER_87_591 VDD VSS sg13cmos5l_decap_8
XFILLER_74_241 VDD VSS sg13cmos5l_decap_8
XFILLER_74_252 VDD VSS sg13cmos5l_decap_4
XFILLER_74_274 VDD VSS sg13cmos5l_fill_1
XFILLER_75_786 VDD VSS sg13cmos5l_decap_8
XFILLER_42_171 VDD VSS sg13cmos5l_decap_8
X_4480_ _4482_/A _4480_/A VDD VSS sg13cmos5l_inv_1
X_6150_ _6151_/B _6150_/A _6149_/Y VDD VSS sg13cmos5l_nor2b_1
X_5101_ _5102_/A _5101_/A _5101_/B VDD VSS sg13cmos5l_xor2_1
X_6081_ _6108_/B _6061_/B _5788_/A _6081_/S VDD VSS sg13cmos5l_mux2_1
XFILLER_38_400 VDD VSS sg13cmos5l_fill_1
X_5032_ _5041_/A _5042_/B _5042_/A VDD VSS sg13cmos5l_xor2_1
XFILLER_122_19 VDD VSS sg13cmos5l_fill_2
XFILLER_54_915 VDD VSS sg13cmos5l_fill_2
XFILLER_38_499 VDD VSS sg13cmos5l_decap_8
XFILLER_65_285 VDD VSS sg13cmos5l_decap_4
X_6983_ _6983_/Y _6967_/Y _6982_/Y _7302_/A1 VDD VSS sg13cmos5l_a21oi_1
XFILLER_81_756 VDD VSS sg13cmos5l_decap_8
XFILLER_40_108 VDD VSS sg13cmos5l_fill_2
X_5934_ _5935_/B _5934_/A _5936_/B VDD VSS sg13cmos5l_nand2_1
X_5865_ _5866_/B _5865_/A _5893_/A VDD VSS sg13cmos5l_xnor2_1
X_7604_ _7604_/Y _7477_/B _7478_/B _7585_/A VDD VSS sg13cmos5l_a21oi_1
X_4816_ _4817_/B _4863_/A _4863_/B VDD VSS sg13cmos5l_xor2_1
XFILLER_31_16 VDD VSS sg13cmos5l_decap_4
X_5796_ _5799_/A _5857_/S _5796_/B VDD VSS sg13cmos5l_xnor2_1
X_7535_ _7615_/D _7534_/Y _7543_/A VDD VSS sg13cmos5l_nand2b_1
X_4747_ _4776_/A _4710_/B _4710_/A _4746_/Y VDD VSS sg13cmos5l_a21oi_1
X_7466_ _7598_/B _7460_/B _7603_/A VDD VSS sg13cmos5l_nand2b_1
X_4678_ _4679_/B _4988_/A _4678_/B VDD VSS sg13cmos5l_xnor2_1
X_7397_ _7399_/A _7397_/A _7483_/B VDD VSS sg13cmos5l_nor2_1
X_6348_ _6349_/A _6368_/B _6347_/Y _6372_/C VDD VSS sg13cmos5l_o21ai_1
X_6279_ _6517_/C _6279_/A VDD VSS sg13cmos5l_inv_1
XFILLER_88_355 VDD VSS sg13cmos5l_fill_1
XFILLER_76_539 VDD VSS sg13cmos5l_fill_1
XFILLER_45_904 VDD VSS sg13cmos5l_decap_8
XFILLER_84_583 VDD VSS sg13cmos5l_decap_8
XFILLER_72_23 VDD VSS sg13cmos5l_fill_1
XFILLER_52_480 VDD VSS sg13cmos5l_decap_4
XFILLER_71_288 VDD VSS sg13cmos5l_fill_1
XFILLER_79_333 VDD VSS sg13cmos5l_fill_2
XFILLER_79_322 VDD VSS sg13cmos5l_decap_8
XFILLER_79_355 VDD VSS sg13cmos5l_decap_8
XFILLER_67_517 VDD VSS sg13cmos5l_decap_8
XFILLER_67_539 VDD VSS sg13cmos5l_decap_4
XFILLER_48_797 VDD VSS sg13cmos5l_fill_1
XFILLER_63_745 VDD VSS sg13cmos5l_decap_8
XFILLER_63_756 VDD VSS sg13cmos5l_fill_2
Xplace701 _7018_/B _7082_/B VDD VSS sg13cmos5l_buf_1
Xplace712 _6929_/B _6934_/S VDD VSS sg13cmos5l_buf_1
Xplace723 _4988_/A _5432_/A VDD VSS sg13cmos5l_buf_1
XFILLER_46_90 VDD VSS sg13cmos5l_decap_8
XFILLER_62_244 VDD VSS sg13cmos5l_fill_1
XFILLER_62_266 VDD VSS sg13cmos5l_fill_2
Xplace734 _4322_/A _4168_/A VDD VSS sg13cmos5l_buf_1
Xplace745 place745/X place754/A VDD VSS sg13cmos5l_buf_1
X_5650_ _5650_/Y _5650_/A _5650_/B VDD VSS sg13cmos5l_nor2_1
X_4601_ _4602_/B _4658_/B _4658_/A VDD VSS sg13cmos5l_xor2_1
X_5581_ _5582_/B _5641_/B1 _3996_/Y _5274_/A _5756_/B2 VDD VSS sg13cmos5l_a22oi_1
X_7320_ _7320_/Y _7320_/A _7328_/B VDD VSS sg13cmos5l_nor2_1
X_4532_ _4581_/B _4532_/A _4532_/B VDD VSS sg13cmos5l_xnor2_1
Xrebuffer2004 _4242_/B _4241_/Y VDD VSS sg13cmos5l_buf_1
X_7251_ _7251_/Y _7298_/A1 _7068_/Y _7250_/Y VDD VSS sg13cmos5l_o21ai_1
X_4463_ _4464_/B _4463_/A _4463_/B VDD VSS sg13cmos5l_xor2_1
Xrebuffer2015 _5487_/A _5489_/A VDD VSS sg13cmos5l_buf_1
Xrebuffer2026 place530/A _6255_/Y VDD VSS sg13cmos5l_buf_2
Xrebuffer2037 _7547_/A _7332_/A VDD VSS sg13cmos5l_buf_1
X_6202_ _6202_/Y _6205_/A _6202_/B VDD VSS sg13cmos5l_nor2_1
Xrebuffer1303 rebuffer1303/X rebuffer1304/X VDD VSS sg13cmos5l_buf_1
Xrebuffer2048 _6814_/B _6383_/B VDD VSS sg13cmos5l_buf_1
Xrebuffer2059 _7551_/A _7325_/A VDD VSS sg13cmos5l_buf_1
Xrebuffer1325 _6769_/A1 _6573_/A VDD VSS sg13cmos5l_buf_1
Xrebuffer1314 rebuffer1314/X rebuffer1315/X VDD VSS sg13cmos5l_buf_1
X_7182_ _7234_/B _7182_/A VDD VSS sg13cmos5l_inv_1
X_4394_ _4440_/B _4532_/A _4394_/B VDD VSS sg13cmos5l_xnor2_1
Xrebuffer1369 rebuffer1369/X rebuffer1370/X VDD VSS sg13cmos5l_buf_1
Xrebuffer1358 rebuffer1358/X rebuffer1359/X VDD VSS sg13cmos5l_buf_1
Xrebuffer1347 rebuffer1347/X rebuffer1348/X VDD VSS sg13cmos5l_buf_1
Xrebuffer1336 rebuffer1336/X rebuffer1337/X VDD VSS sg13cmos5l_buf_1
X_6133_ _6134_/B _6105_/B _6105_/A _6132_/X VDD VSS sg13cmos5l_a21o_1
XFILLER_86_815 VDD VSS sg13cmos5l_decap_8
X_6064_ _6094_/A _6123_/B _6089_/A VDD VSS sg13cmos5l_xnor2_1
X_5015_ _5015_/Y _5015_/A _5015_/B VDD VSS sg13cmos5l_nor2_1
XFILLER_39_764 VDD VSS sg13cmos5l_decap_8
XFILLER_26_16 VDD VSS sg13cmos5l_decap_4
XFILLER_54_734 VDD VSS sg13cmos5l_decap_4
XFILLER_54_745 VDD VSS sg13cmos5l_decap_8
XFILLER_42_907 VDD VSS sg13cmos5l_decap_8
X_6966_ _7221_/B _6959_/Y _7142_/B _6965_/Y VDD VSS sg13cmos5l_a21oi_1
XFILLER_81_542 VDD VSS sg13cmos5l_decap_4
X_5917_ _5962_/A _5957_/B _5917_/B VDD VSS sg13cmos5l_xor2_1
XFILLER_42_26 VDD VSS sg13cmos5l_decap_8
X_6897_ _7045_/B _6721_/Y _6918_/B VDD VSS sg13cmos5l_nand2b_1
X_5848_ _5889_/A _5848_/A _5848_/B _5848_/C VDD VSS sg13cmos5l_nand3_1
X_5779_ _5780_/B _5840_/B _5840_/A VDD VSS sg13cmos5l_xnor2_1
X_7518_ _7520_/A _7518_/A _7518_/B VDD VSS sg13cmos5l_nand2_1
X_7449_ _7453_/A _7590_/A _7589_/A _7590_/B VDD VSS sg13cmos5l_nand3_1
XFILLER_88_130 VDD VSS sg13cmos5l_fill_2
Xrebuffer1881 _4189_/A _4143_/A VDD VSS sg13cmos5l_buf_1
Xrebuffer1870 _4192_/A _4187_/A VDD VSS sg13cmos5l_buf_1
XFILLER_77_837 VDD VSS sg13cmos5l_decap_8
XFILLER_76_303 VDD VSS sg13cmos5l_fill_2
Xrebuffer1892 _5934_/A _5936_/A VDD VSS sg13cmos5l_buf_1
XFILLER_88_196 VDD VSS sg13cmos5l_decap_4
XFILLER_45_712 VDD VSS sg13cmos5l_decap_8
XFILLER_85_870 VDD VSS sg13cmos5l_decap_8
XFILLER_76_369 VDD VSS sg13cmos5l_fill_2
XFILLER_68_859 VDD VSS sg13cmos5l_decap_8
XFILLER_48_572 VDD VSS sg13cmos5l_decap_4
Xplace520 _5370_/B2 _4496_/Y VDD VSS sg13cmos5l_buf_1
Xplace531 _6082_/A2 _6136_/A VDD VSS sg13cmos5l_buf_1
X_6820_ _6822_/A _6820_/A _6820_/B VDD VSS sg13cmos5l_nand2_1
Xplace542 _6084_/B2 _4365_/Y VDD VSS sg13cmos5l_buf_1
Xplace553 _4378_/A2 _4158_/Y VDD VSS sg13cmos5l_buf_1
Xplace564 _4271_/B2 _4017_/Y VDD VSS sg13cmos5l_buf_1
Xplace575 _7585_/A _7431_/B VDD VSS sg13cmos5l_buf_1
Xplace586 _7299_/A1 _7111_/A VDD VSS sg13cmos5l_buf_1
Xplace597 _6979_/B _6255_/C VDD VSS sg13cmos5l_buf_1
X_6751_ _7210_/C _6751_/A _7162_/B VDD VSS sg13cmos5l_nand2_1
X_6682_ _6684_/A _6680_/Y _6689_/A VDD VSS sg13cmos5l_nand2b_1
X_5702_ _5749_/B _5702_/A _5702_/B VDD VSS sg13cmos5l_xnor2_1
X_5564_ _5594_/A _5564_/A _5564_/B VDD VSS sg13cmos5l_xor2_1
X_7303_ _7559_/A _7307_/B _7303_/B VDD VSS sg13cmos5l_xnor2_1
X_4515_ _4568_/B _4692_/A _4515_/B VDD VSS sg13cmos5l_xnor2_1
Xoutput910 bank_B_rdata[18] output910/A VDD VSS sg13cmos5l_buf_1
Xoutput921 bank_B_rdata[28] wire965/X VDD VSS sg13cmos5l_buf_1
X_5495_ _5496_/B _5747_/A _5495_/B VDD VSS sg13cmos5l_xnor2_1
Xoutput932 bank_B_rdata[9] output932/A VDD VSS sg13cmos5l_buf_1
X_7234_ _7234_/Y _7234_/A _7234_/B VDD VSS sg13cmos5l_nand2_1
X_4446_ _4447_/C _4446_/A VDD VSS sg13cmos5l_inv_1
X_7165_ _7166_/A _7027_/A _7030_/B _7164_/Y VDD VSS sg13cmos5l_a21oi_1
X_4377_ _4426_/A _4871_/A _4377_/B VDD VSS sg13cmos5l_xnor2_1
XFILLER_58_303 VDD VSS sg13cmos5l_decap_8
X_6116_ _6142_/B _6139_/B _6139_/A VDD VSS sg13cmos5l_xnor2_1
XFILLER_86_612 VDD VSS sg13cmos5l_decap_8
XFILLER_37_15 VDD VSS sg13cmos5l_fill_2
X_7096_ _7642_/B _7096_/A _7715_/Q _7096_/C VDD VSS sg13cmos5l_nand3_1
XFILLER_39_550 VDD VSS sg13cmos5l_decap_4
XFILLER_73_317 VDD VSS sg13cmos5l_decap_4
XFILLER_74_829 VDD VSS sg13cmos5l_decap_8
X_6047_ _7700_/D _6047_/A _6047_/B_N VDD VSS sg13cmos5l_nor2b_1
XFILLER_86_689 VDD VSS sg13cmos5l_decap_8
XFILLER_67_881 VDD VSS sg13cmos5l_decap_8
XFILLER_82_895 VDD VSS sg13cmos5l_decap_8
X_6949_ _6949_/X _7085_/A _7072_/B VDD VSS sg13cmos5l_and2_1
XFILLER_41_269 VDD VSS sg13cmos5l_decap_4
XFILLER_78_22 VDD VSS sg13cmos5l_decap_4
XFILLER_77_601 VDD VSS sg13cmos5l_fill_1
XFILLER_76_100 VDD VSS sg13cmos5l_fill_1
XFILLER_49_336 VDD VSS sg13cmos5l_fill_1
XFILLER_76_111 VDD VSS sg13cmos5l_decap_4
XFILLER_64_317 VDD VSS sg13cmos5l_decap_8
XFILLER_65_829 VDD VSS sg13cmos5l_decap_8
XFILLER_77_667 VDD VSS sg13cmos5l_decap_8
XFILLER_58_881 VDD VSS sg13cmos5l_decap_8
XFILLER_64_328 VDD VSS sg13cmos5l_decap_8
XFILLER_45_542 VDD VSS sg13cmos5l_fill_1
XFILLER_73_873 VDD VSS sg13cmos5l_decap_8
X_5280_ _5281_/B _5328_/A _5328_/B VDD VSS sg13cmos5l_xor2_1
X_4300_ _6110_/A _4374_/A _4300_/B VDD VSS sg13cmos5l_nand2_1
X_4231_ _4250_/A _4231_/A1 _4185_/B _4230_/X VDD VSS sg13cmos5l_a21o_1
XFILLER_87_409 VDD VSS sg13cmos5l_decap_8
X_4162_ _4163_/B _4162_/A1 _4378_/A2 _3999_/B _4378_/B2 VDD VSS sg13cmos5l_a22oi_1
X_4093_ _4094_/A _4093_/A _4093_/B VDD VSS sg13cmos5l_xnor2_1
XFILLER_49_892 VDD VSS sg13cmos5l_decap_8
XFILLER_55_317 VDD VSS sg13cmos5l_fill_1
XFILLER_64_862 VDD VSS sg13cmos5l_decap_8
XFILLER_82_136 VDD VSS sg13cmos5l_decap_8
X_6803_ _6803_/Y _7659_/Q _6803_/B VDD VSS sg13cmos5l_xnor2_1
X_4995_ _5023_/A _4955_/B _4955_/A _4994_/Y VDD VSS sg13cmos5l_a21oi_1
XFILLER_51_567 VDD VSS sg13cmos5l_fill_2
X_6734_ _6735_/B _6734_/A _6734_/B VDD VSS sg13cmos5l_nand2_1
X_3946_ _3947_/A _4172_/A _3946_/B VDD VSS sg13cmos5l_nand2_1
X_6665_ _6665_/Y _6665_/A _6665_/B VDD VSS sg13cmos5l_nor2_1
X_6596_ _6598_/A _6603_/B _6603_/A VDD VSS sg13cmos5l_xnor2_1
X_5616_ _5617_/B _5616_/A _5618_/B VDD VSS sg13cmos5l_nand2_1
X_5547_ _5780_/A _5547_/A VDD VSS sg13cmos5l_buf_1
X_5478_ _5548_/A _5415_/B _5480_/A _5477_/X VDD VSS sg13cmos5l_a21oi_1
Xbank_A_sram.gen_ihp_256x32.u_sram_256x32_1177 bank_A_sram.gen_ihp_256x32.u_sram_256x32/A_BM[2]
+ VDD VSS sg13cmos5l_tiehi
X_7217_ _7232_/A _7217_/A _7217_/B _7536_/A VDD VSS sg13cmos5l_nand3_1
XFILLER_48_14 VDD VSS sg13cmos5l_fill_1
Xbank_A_sram.gen_ihp_256x32.u_sram_256x32_1188 bank_A_sram.gen_ihp_256x32.u_sram_256x32/A_BM[13]
+ VDD VSS sg13cmos5l_tiehi
Xbank_A_sram.gen_ihp_256x32.u_sram_256x32_1199 bank_A_sram.gen_ihp_256x32.u_sram_256x32/A_BM[24]
+ VDD VSS sg13cmos5l_tiehi
X_7148_ _7149_/A _7176_/B _7176_/A VDD VSS sg13cmos5l_nor2_1
XFILLER_86_442 VDD VSS sg13cmos5l_fill_2
XFILLER_104_20 VDD VSS sg13cmos5l_fill_1
XFILLER_58_166 VDD VSS sg13cmos5l_decap_8
Xbank_B_sram.gen_ihp_256x32.u_sram_256x32_1120 bank_B_sram.gen_ihp_256x32.u_sram_256x32_1120/L_LO
+ VDD VSS sg13cmos5l_tielo
Xbank_B_sram.gen_ihp_256x32.u_sram_256x32_1131 bank_B_sram.gen_ihp_256x32.u_sram_256x32_1131/L_LO
+ VDD VSS sg13cmos5l_tielo
X_7079_ _7081_/A _6961_/Y _7085_/B _7078_/X VDD VSS sg13cmos5l_a21oi_1
XFILLER_86_475 VDD VSS sg13cmos5l_decap_8
XFILLER_39_380 VDD VSS sg13cmos5l_fill_1
Xbank_B_sram.gen_ihp_256x32.u_sram_256x32_1142 bank_B_sram.gen_ihp_256x32.u_sram_256x32_1142/L_LO
+ VDD VSS sg13cmos5l_tielo
Xbank_B_sram.gen_ihp_256x32.u_sram_256x32_1153 bank_B_sram.gen_ihp_256x32.u_sram_256x32_1153/L_LO
+ VDD VSS sg13cmos5l_tielo
Xbank_B_sram.gen_ihp_256x32.u_sram_256x32_1164 bank_B_sram.gen_ihp_256x32.u_sram_256x32_1164/L_LO
+ VDD VSS sg13cmos5l_tielo
XFILLER_64_35 VDD VSS sg13cmos5l_fill_1
XFILLER_73_158 VDD VSS sg13cmos5l_decap_8
XFILLER_54_350 VDD VSS sg13cmos5l_fill_1
XFILLER_55_895 VDD VSS sg13cmos5l_decap_8
XFILLER_70_854 VDD VSS sg13cmos5l_decap_8
XFILLER_82_692 VDD VSS sg13cmos5l_decap_8
XFILLER_9_19 VDD VSS sg13cmos5l_fill_2
XFILLER_77_420 VDD VSS sg13cmos5l_fill_1
XFILLER_38_807 VDD VSS sg13cmos5l_decap_8
XFILLER_65_604 VDD VSS sg13cmos5l_fill_2
XFILLER_37_328 VDD VSS sg13cmos5l_decap_4
XFILLER_46_862 VDD VSS sg13cmos5l_decap_8
XFILLER_45_361 VDD VSS sg13cmos5l_fill_2
XFILLER_64_169 VDD VSS sg13cmos5l_fill_1
XFILLER_80_618 VDD VSS sg13cmos5l_decap_8
XFILLER_72_191 VDD VSS sg13cmos5l_decap_4
XFILLER_61_865 VDD VSS sg13cmos5l_decap_8
X_4780_ _4781_/B _4780_/A _4780_/B VDD VSS sg13cmos5l_nand2_1
XFILLER_60_375 VDD VSS sg13cmos5l_decap_4
X_6450_ _6452_/A _6451_/A _6450_/A2 _7677_/Q VDD VSS sg13cmos5l_a21oi_1
X_6381_ _6382_/A _6380_/Y _6389_/A _6381_/B1 VDD VSS sg13cmos5l_o21ai_1
X_5401_ _5402_/B _5453_/A _5453_/B VDD VSS sg13cmos5l_xor2_1
XFILLER_48_0 VDD VSS sg13cmos5l_fill_1
X_5263_ _5314_/B _5702_/A _5263_/B VDD VSS sg13cmos5l_xnor2_1
X_7002_ _7002_/Y _7002_/A _7002_/B VDD VSS sg13cmos5l_nand2_1
X_5194_ _5249_/B _5194_/A _5194_/B VDD VSS sg13cmos5l_xnor2_1
X_4214_ _4215_/B _4056_/A _3999_/A wire982/X _4271_/B2 VDD VSS sg13cmos5l_a22oi_1
XFILLER_56_615 VDD VSS sg13cmos5l_fill_1
X_4145_ _4243_/C _4145_/A _4142_/A VDD VSS sg13cmos5l_nor2b_2
XFILLER_83_423 VDD VSS sg13cmos5l_decap_8
XFILLER_83_412 VDD VSS sg13cmos5l_decap_8
XFILLER_37_862 VDD VSS sg13cmos5l_fill_2
XFILLER_37_895 VDD VSS sg13cmos5l_decap_4
XFILLER_64_670 VDD VSS sg13cmos5l_decap_4
XFILLER_51_353 VDD VSS sg13cmos5l_fill_2
XFILLER_52_887 VDD VSS sg13cmos5l_decap_8
X_4978_ _4980_/A _4978_/A _4978_/B VDD VSS sg13cmos5l_nand2_1
X_7697_ _7697_/Q _7702_/CLK _7697_/D place751/X VDD VSS sg13cmos5l_dfrbpq_1
Xclkload4 clkload4/Y clkload4/A VDD VSS sg13cmos5l_inv_1
X_6579_ _6587_/B _6579_/A _6579_/B VDD VSS sg13cmos5l_nand2_2
XFILLER_87_773 VDD VSS sg13cmos5l_decap_8
XFILLER_47_637 VDD VSS sg13cmos5l_fill_1
XFILLER_61_106 VDD VSS sg13cmos5l_fill_1
XFILLER_74_489 VDD VSS sg13cmos5l_decap_4
XFILLER_43_843 VDD VSS sg13cmos5l_decap_8
XFILLER_70_640 VDD VSS sg13cmos5l_decap_8
XFILLER_49_90 VDD VSS sg13cmos5l_fill_2
XFILLER_84_209 VDD VSS sg13cmos5l_fill_1
XFILLER_1_20 VDD VSS sg13cmos5l_fill_1
XFILLER_38_637 VDD VSS sg13cmos5l_fill_1
X_5950_ _5951_/B _6058_/B1 _6084_/A2 _6026_/B1 _6084_/B2 VDD VSS sg13cmos5l_a22oi_1
XFILLER_46_681 VDD VSS sg13cmos5l_fill_1
X_4901_ _4902_/B _4835_/A _4901_/B VDD VSS sg13cmos5l_nand2b_1
XFILLER_61_673 VDD VSS sg13cmos5l_fill_1
X_7620_ _7621_/C _7620_/A _7620_/B _7620_/C _7620_/D VDD VSS sg13cmos5l_nand4_1
X_5881_ _5891_/A _5881_/A _5922_/A VDD VSS sg13cmos5l_xnor2_1
X_4832_ _4833_/B _4832_/A _4832_/B VDD VSS sg13cmos5l_xor2_1
XFILLER_60_194 VDD VSS sg13cmos5l_decap_4
X_7551_ _7552_/B _7551_/A _7551_/B VDD VSS sg13cmos5l_nand2_1
X_4763_ _4773_/A _5141_/A _4763_/B VDD VSS sg13cmos5l_xnor2_1
X_7482_ _7483_/A _7484_/A _7484_/C VDD VSS sg13cmos5l_nand2_2
X_6502_ _6506_/B _6502_/A _7683_/Q _6502_/C VDD VSS sg13cmos5l_nand3_1
X_4694_ _4710_/A _4694_/A _4694_/B VDD VSS sg13cmos5l_xor2_1
X_6433_ _6434_/B _6430_/Y _6442_/A _6450_/A2 VDD VSS sg13cmos5l_o21ai_1
X_6364_ _6815_/B _6364_/A _6364_/B VDD VSS sg13cmos5l_nand2_2
X_6295_ _6305_/B _6295_/A _6295_/B VDD VSS sg13cmos5l_nand2_2
X_5315_ _5366_/B _5265_/B _5265_/A _5314_/X VDD VSS sg13cmos5l_a21oi_1
X_5246_ _5247_/B _5430_/B1 _5623_/A2 _5370_/B1 _5246_/B2 VDD VSS sg13cmos5l_a22oi_1
XFILLER_57_902 VDD VSS sg13cmos5l_decap_8
XFILLER_69_773 VDD VSS sg13cmos5l_fill_1
X_5177_ _5185_/A _5122_/B _4967_/A _5177_/S VDD VSS sg13cmos5l_mux2_1
X_4128_ _4129_/B _4172_/A _4172_/B _4128_/C VDD VSS sg13cmos5l_nor3_1
XFILLER_84_765 VDD VSS sg13cmos5l_decap_8
XFILLER_44_629 VDD VSS sg13cmos5l_fill_1
X_4059_ _4079_/A _4172_/B _4023_/A _4058_/Y VDD VSS sg13cmos5l_a21o_1
XFILLER_83_275 VDD VSS sg13cmos5l_decap_4
XFILLER_71_437 VDD VSS sg13cmos5l_decap_8
XFILLER_40_802 VDD VSS sg13cmos5l_decap_8
XFILLER_40_879 VDD VSS sg13cmos5l_decap_8
XFILLER_51_183 VDD VSS sg13cmos5l_decap_8
XFILLER_79_537 VDD VSS sg13cmos5l_decap_4
Xinput810 input810/X bank_B_wdata[15] VDD VSS sg13cmos5l_buf_1
Xinput821 input821/X bank_B_wdata[25] VDD VSS sg13cmos5l_buf_1
XFILLER_47_423 VDD VSS sg13cmos5l_fill_1
Xinput832 input832/X bank_B_wdata[6] VDD VSS sg13cmos5l_buf_1
Xinput843 _7708_/D quant_cfg[17] VDD VSS sg13cmos5l_buf_1
Xinput854 _7719_/D quant_cfg[28] VDD VSS sg13cmos5l_buf_1
XFILLER_86_99 VDD VSS sg13cmos5l_fill_1
XFILLER_75_765 VDD VSS sg13cmos5l_fill_2
XFILLER_43_640 VDD VSS sg13cmos5l_fill_1
XFILLER_43_695 VDD VSS sg13cmos5l_fill_2
X_6080_ _6124_/B _6062_/A _6062_/B _6079_/Y VDD VSS sg13cmos5l_a21o_1
X_5100_ _5101_/B _5108_/B _5108_/A VDD VSS sg13cmos5l_xor2_1
X_5031_ _5042_/A _4962_/B _4962_/A _5030_/X VDD VSS sg13cmos5l_a21o_1
XFILLER_78_592 VDD VSS sg13cmos5l_decap_4
XFILLER_38_467 VDD VSS sg13cmos5l_fill_1
XFILLER_38_478 VDD VSS sg13cmos5l_decap_8
XFILLER_65_264 VDD VSS sg13cmos5l_decap_8
XFILLER_65_275 VDD VSS sg13cmos5l_fill_2
X_6982_ _6982_/Y _7141_/A _6982_/B VDD VSS sg13cmos5l_nor2_1
XFILLER_81_735 VDD VSS sg13cmos5l_decap_8
XFILLER_15_18 VDD VSS sg13cmos5l_fill_2
X_5933_ _5936_/B _5933_/A _5933_/B VDD VSS sg13cmos5l_nand2_1
XFILLER_80_245 VDD VSS sg13cmos5l_fill_2
X_5864_ _5893_/A _5808_/B _5808_/A _5863_/X VDD VSS sg13cmos5l_a21oi_1
X_7603_ _7607_/A _7603_/A _7603_/B VDD VSS sg13cmos5l_xnor2_1
X_4815_ _4863_/B _5194_/A _4815_/B VDD VSS sg13cmos5l_xnor2_1
X_7534_ _7534_/Y _7534_/A1 _7531_/B _7245_/B VDD VSS sg13cmos5l_a21oi_1
X_5795_ _5796_/B _6085_/A _5795_/B VDD VSS sg13cmos5l_xnor2_1
X_4746_ _4746_/Y _4746_/A _4709_/B VDD VSS sg13cmos5l_nor2b_1
X_7465_ _7469_/A _7465_/A _7597_/B VDD VSS sg13cmos5l_nor2b_1
X_4677_ _4678_/B _4739_/B1 _4303_/A _4738_/A1 _4800_/B2 VDD VSS sg13cmos5l_a22oi_1
X_7396_ _7503_/A _7431_/B _7410_/A VDD VSS sg13cmos5l_xnor2_1
X_6416_ _6418_/A _7712_/Q _6698_/A VDD VSS sg13cmos5l_nor2_1
X_6347_ _6347_/Y _6347_/A _6346_/A VDD VSS sg13cmos5l_nor2b_1
XFILLER_57_710 VDD VSS sg13cmos5l_fill_1
XFILLER_57_721 VDD VSS sg13cmos5l_fill_1
X_5229_ _5230_/B _5229_/A VDD VSS sg13cmos5l_inv_1
XFILLER_88_378 VDD VSS sg13cmos5l_fill_1
XFILLER_84_562 VDD VSS sg13cmos5l_decap_8
XFILLER_112_20 VDD VSS sg13cmos5l_fill_1
XFILLER_56_275 VDD VSS sg13cmos5l_decap_8
XFILLER_72_35 VDD VSS sg13cmos5l_fill_1
XFILLER_72_57 VDD VSS sg13cmos5l_decap_8
XFILLER_47_242 VDD VSS sg13cmos5l_decap_4
XFILLER_75_562 VDD VSS sg13cmos5l_fill_1
XFILLER_62_212 VDD VSS sg13cmos5l_fill_2
Xplace702 _7082_/B _6976_/B VDD VSS sg13cmos5l_buf_1
Xplace713 _6934_/S _6800_/A VDD VSS sg13cmos5l_buf_1
XFILLER_75_595 VDD VSS sg13cmos5l_fill_1
XFILLER_63_768 VDD VSS sg13cmos5l_decap_8
Xplace724 _5432_/A _5747_/A VDD VSS sg13cmos5l_buf_1
Xplace735 _5645_/A _3995_/A VDD VSS sg13cmos5l_buf_1
Xplace746 place746/X place747/X VDD VSS sg13cmos5l_buf_1
XFILLER_43_470 VDD VSS sg13cmos5l_fill_1
X_4600_ _4658_/A _4535_/A _4598_/Y _4599_/Y VDD VSS sg13cmos5l_o21ai_1
X_5580_ _5650_/A _5525_/B _5525_/A _5579_/X VDD VSS sg13cmos5l_a21oi_1
X_4531_ _4532_/B _4389_/A _4592_/A2 _4326_/A _4531_/B2 VDD VSS sg13cmos5l_a22oi_1
X_7250_ _7250_/Y _7297_/A _7250_/B VDD VSS sg13cmos5l_nor2_1
X_4462_ _4463_/B _4403_/B _4403_/A _4461_/X VDD VSS sg13cmos5l_a21o_1
Xrebuffer2005 _4182_/B _4135_/A VDD VSS sg13cmos5l_buf_1
Xrebuffer2027 _6314_/B _6305_/B VDD VSS sg13cmos5l_buf_2
X_6201_ _6201_/Y _6201_/A VDD VSS sg13cmos5l_inv_1
Xrebuffer1304 rebuffer1304/X rebuffer1305/X VDD VSS sg13cmos5l_buf_1
Xrebuffer2038 _7220_/A2 _6938_/Y VDD VSS sg13cmos5l_buf_1
Xrebuffer2049 _6823_/B _6414_/A VDD VSS sg13cmos5l_buf_1
Xrebuffer1326 _6799_/B _6286_/A VDD VSS sg13cmos5l_buf_1
Xrebuffer1315 rebuffer1315/X rebuffer1316/X VDD VSS sg13cmos5l_buf_1
X_7181_ _7182_/A _7294_/B _7483_/B VDD VSS sg13cmos5l_nor2_1
X_4393_ _4394_/B _4275_/A _4592_/A2 _4218_/A _4531_/B2 VDD VSS sg13cmos5l_a22oi_1
XFILLER_30_0 VDD VSS sg13cmos5l_fill_1
Xrebuffer1359 rebuffer1359/X rebuffer1360/X VDD VSS sg13cmos5l_buf_1
Xrebuffer1348 rebuffer1348/X rebuffer1349/X VDD VSS sg13cmos5l_buf_1
Xrebuffer1337 rebuffer1337/X rebuffer1338/X VDD VSS sg13cmos5l_buf_1
X_6132_ _6132_/X _6132_/A _6132_/B VDD VSS sg13cmos5l_and2_1
X_6063_ _6089_/A _6063_/A _6079_/A VDD VSS sg13cmos5l_xor2_1
X_5014_ _5015_/B _5460_/A _5206_/B _5014_/C VDD VSS sg13cmos5l_nor3_1
XFILLER_38_231 VDD VSS sg13cmos5l_fill_1
XFILLER_66_562 VDD VSS sg13cmos5l_decap_4
X_6965_ _6965_/Y _7142_/B _7142_/A VDD VSS sg13cmos5l_nor2_1
XFILLER_81_565 VDD VSS sg13cmos5l_fill_2
X_5916_ _5917_/B _5916_/A _5916_/B VDD VSS sg13cmos5l_xnor2_1
X_6896_ _7045_/A _6896_/A _6901_/A VDD VSS sg13cmos5l_nand2_1
X_5847_ _7695_/D _5847_/A _5847_/B VDD VSS sg13cmos5l_xnor2_1
X_5778_ _5840_/A _5834_/A _5835_/B VDD VSS sg13cmos5l_xnor2_1
X_7517_ _7619_/B _7516_/Y _7517_/B VDD VSS sg13cmos5l_nand2b_1
X_4729_ _7677_/D _4729_/A _4729_/B VDD VSS sg13cmos5l_xnor2_1
X_7448_ _7590_/B _7443_/B _7460_/A VDD VSS sg13cmos5l_nand2b_1
X_7379_ _7381_/B _7380_/B _7385_/A VDD VSS sg13cmos5l_xnor2_1
Xrebuffer1882 _5423_/B _5485_/A VDD VSS sg13cmos5l_buf_1
Xrebuffer1871 _4110_/A _4094_/A VDD VSS sg13cmos5l_buf_1
XFILLER_88_164 VDD VSS sg13cmos5l_decap_4
XFILLER_77_816 VDD VSS sg13cmos5l_decap_8
XFILLER_67_68 VDD VSS sg13cmos5l_decap_8
Xrebuffer1893 _5734_/A rebuffer1964/X VDD VSS sg13cmos5l_buf_1
XFILLER_44_212 VDD VSS sg13cmos5l_decap_8
XFILLER_57_584 VDD VSS sg13cmos5l_fill_2
XFILLER_57_595 VDD VSS sg13cmos5l_decap_4
XFILLER_72_554 VDD VSS sg13cmos5l_fill_2
XFILLER_79_120 VDD VSS sg13cmos5l_fill_1
XFILLER_68_838 VDD VSS sg13cmos5l_decap_8
XFILLER_79_153 VDD VSS sg13cmos5l_decap_4
XFILLER_63_510 VDD VSS sg13cmos5l_fill_2
XFILLER_76_882 VDD VSS sg13cmos5l_decap_8
Xplace510 _7472_/B1 _7399_/Y VDD VSS sg13cmos5l_buf_1
Xplace521 _6461_/C _6450_/A2 VDD VSS sg13cmos5l_buf_1
Xplace532 _6136_/A _5493_/A2 VDD VSS sg13cmos5l_buf_1
Xplace543 _4800_/B2 _5246_/B2 VDD VSS sg13cmos5l_buf_1
Xplace554 _5869_/B2 _4074_/Y VDD VSS sg13cmos5l_buf_1
Xplace565 _5756_/B2 _4017_/Y VDD VSS sg13cmos5l_buf_1
XFILLER_51_749 VDD VSS sg13cmos5l_fill_1
Xplace576 _7431_/B _7380_/B VDD VSS sg13cmos5l_buf_1
Xplace587 _7301_/A2 _7111_/A VDD VSS sg13cmos5l_buf_1
Xplace598 _6084_/A2 _4301_/Y VDD VSS sg13cmos5l_buf_1
X_5701_ _5702_/B _6026_/B1 _5871_/A2 _5985_/B1 _5871_/B2 VDD VSS sg13cmos5l_a22oi_1
X_3962_ _3966_/A _4447_/B _3972_/B _3976_/B VDD VSS sg13cmos5l_o21ai_1
X_6681_ _6689_/A _6681_/A _6681_/B _6681_/C VDD VSS sg13cmos5l_nand3_1
X_5632_ _5639_/A _5982_/A _5632_/B VDD VSS sg13cmos5l_xnor2_1
XFILLER_12_19 VDD VSS sg13cmos5l_fill_2
X_5563_ _5564_/B _5563_/A _5619_/A VDD VSS sg13cmos5l_xnor2_1
XFILLER_78_0 VDD VSS sg13cmos5l_fill_1
X_7302_ _7303_/B _7302_/A1 _7299_/Y _7301_/X VDD VSS sg13cmos5l_o21ai_1
X_4514_ _4515_/B _4800_/B1 _4878_/A2 _4739_/B1 _4878_/B2 VDD VSS sg13cmos5l_a22oi_1
Xoutput900 bank_A_rdata[9] _4171_/A VDD VSS sg13cmos5l_buf_1
Xoutput911 bank_B_rdata[19] output911/A VDD VSS sg13cmos5l_buf_1
X_5494_ _5495_/B _5558_/B1 _5623_/A2 _5557_/A1 _5687_/B2 VDD VSS sg13cmos5l_a22oi_1
Xoutput922 bank_B_rdata[29] wire964/X VDD VSS sg13cmos5l_buf_1
X_7233_ _7234_/A _7233_/A _7233_/B _7233_/C VDD VSS sg13cmos5l_nand3_1
X_4445_ _4448_/A _3972_/A _4446_/A _5204_/B1 VDD VSS sg13cmos5l_a21oi_1
X_7164_ _7164_/Y _7164_/A _7164_/B VDD VSS sg13cmos5l_nor2_1
X_4376_ _4377_/B _4434_/B1 _4753_/A2 _4739_/B1 _4753_/B2 VDD VSS sg13cmos5l_a22oi_1
X_6115_ _6139_/A _5396_/C _4496_/A _6114_/Y VDD VSS sg13cmos5l_o21ai_1
XFILLER_59_849 VDD VSS sg13cmos5l_decap_8
X_7095_ _7641_/A _7122_/B _7716_/Q VDD VSS sg13cmos5l_nand2b_1
XFILLER_85_134 VDD VSS sg13cmos5l_fill_2
XFILLER_67_860 VDD VSS sg13cmos5l_decap_8
XFILLER_74_808 VDD VSS sg13cmos5l_decap_8
X_6046_ _6077_/A _6046_/A _6046_/B _6046_/C VDD VSS sg13cmos5l_nand3_1
XFILLER_86_668 VDD VSS sg13cmos5l_decap_8
XFILLER_41_204 VDD VSS sg13cmos5l_decap_8
XFILLER_53_26 VDD VSS sg13cmos5l_fill_1
XFILLER_54_576 VDD VSS sg13cmos5l_fill_1
XFILLER_54_587 VDD VSS sg13cmos5l_fill_1
XFILLER_82_874 VDD VSS sg13cmos5l_decap_8
XFILLER_41_226 VDD VSS sg13cmos5l_decap_8
X_6948_ _7085_/A _6849_/A _6957_/S _6947_/X VDD VSS sg13cmos5l_a21oi_1
XFILLER_81_395 VDD VSS sg13cmos5l_decap_4
X_6879_ _6879_/Y _6878_/Y _6879_/B VDD VSS sg13cmos5l_nand2b_1
XFILLER_78_89 VDD VSS sg13cmos5l_decap_8
XFILLER_77_646 VDD VSS sg13cmos5l_decap_8
XFILLER_58_860 VDD VSS sg13cmos5l_decap_8
XFILLER_45_521 VDD VSS sg13cmos5l_fill_2
XFILLER_45_554 VDD VSS sg13cmos5l_fill_1
XFILLER_73_852 VDD VSS sg13cmos5l_decap_8
XFILLER_45_598 VDD VSS sg13cmos5l_decap_8
XFILLER_41_782 VDD VSS sg13cmos5l_decap_8
XFILLER_43_70 VDD VSS sg13cmos5l_decap_8
XFILLER_64_6 VDD VSS sg13cmos5l_fill_1
X_4230_ _4230_/X _4230_/A _4230_/B VDD VSS sg13cmos5l_and2_1
XFILLER_68_613 VDD VSS sg13cmos5l_decap_4
XFILLER_68_624 VDD VSS sg13cmos5l_decap_8
XFILLER_68_635 VDD VSS sg13cmos5l_fill_2
XFILLER_68_657 VDD VSS sg13cmos5l_fill_2
XFILLER_55_307 VDD VSS sg13cmos5l_decap_4
XFILLER_56_819 VDD VSS sg13cmos5l_decap_8
X_4092_ _4093_/A _4092_/A _4092_/B VDD VSS sg13cmos5l_xor2_1
XFILLER_49_871 VDD VSS sg13cmos5l_decap_8
XFILLER_67_178 VDD VSS sg13cmos5l_decap_8
XFILLER_83_649 VDD VSS sg13cmos5l_decap_8
XFILLER_48_392 VDD VSS sg13cmos5l_decap_4
XFILLER_64_841 VDD VSS sg13cmos5l_decap_8
X_6802_ _6803_/B _6802_/A _6802_/B VDD VSS sg13cmos5l_nand2_1
X_4994_ _4994_/Y _4994_/A _4954_/B VDD VSS sg13cmos5l_nor2b_1
XFILLER_51_557 VDD VSS sg13cmos5l_fill_1
X_6733_ _6735_/A _6733_/A _6733_/B VDD VSS sg13cmos5l_nand2_1
X_3945_ _5706_/B _4172_/A _3946_/B VDD VSS sg13cmos5l_nor2_1
X_6664_ _6681_/A _6664_/A _6665_/A VDD VSS sg13cmos5l_nor2b_2
X_5615_ _5618_/B _5550_/B _5615_/B VDD VSS sg13cmos5l_nand2b_1
X_6595_ _6603_/B _6611_/A _6595_/B VDD VSS sg13cmos5l_nand2_1
X_5546_ _5615_/B _5546_/A _5546_/B VDD VSS sg13cmos5l_xnor2_1
X_5477_ _5477_/X _5477_/A _5477_/B VDD VSS sg13cmos5l_and2_1
Xbank_A_sram.gen_ihp_256x32.u_sram_256x32_1178 bank_A_sram.gen_ihp_256x32.u_sram_256x32/A_BM[3]
+ VDD VSS sg13cmos5l_tiehi
X_7216_ _7536_/A _7201_/A _7331_/B VDD VSS sg13cmos5l_nand2b_1
X_4428_ _4460_/A _4486_/B _4486_/A VDD VSS sg13cmos5l_xor2_1
Xbank_A_sram.gen_ihp_256x32.u_sram_256x32_1189 bank_A_sram.gen_ihp_256x32.u_sram_256x32/A_BM[14]
+ VDD VSS sg13cmos5l_tiehi
X_7147_ _7176_/A _7131_/Y _7147_/B VDD VSS sg13cmos5l_nand2b_1
X_4359_ _4408_/A _4467_/B VDD VSS sg13cmos5l_inv_1
XFILLER_86_410 VDD VSS sg13cmos5l_fill_2
XFILLER_48_59 VDD VSS sg13cmos5l_fill_1
XFILLER_74_605 VDD VSS sg13cmos5l_decap_8
XFILLER_74_616 VDD VSS sg13cmos5l_fill_1
Xbank_B_sram.gen_ihp_256x32.u_sram_256x32_1110 bank_B_sram.gen_ihp_256x32.u_sram_256x32_1110/L_LO
+ VDD VSS sg13cmos5l_tielo
Xbank_B_sram.gen_ihp_256x32.u_sram_256x32_1121 bank_B_sram.gen_ihp_256x32.u_sram_256x32_1121/L_LO
+ VDD VSS sg13cmos5l_tielo
X_7078_ _7078_/X _7078_/A _7078_/B VDD VSS sg13cmos5l_and2_1
XFILLER_58_189 VDD VSS sg13cmos5l_fill_1
Xbank_B_sram.gen_ihp_256x32.u_sram_256x32_1132 bank_B_sram.gen_ihp_256x32.u_sram_256x32_1132/L_LO
+ VDD VSS sg13cmos5l_tielo
Xbank_B_sram.gen_ihp_256x32.u_sram_256x32_1143 bank_B_sram.gen_ihp_256x32.u_sram_256x32_1143/L_LO
+ VDD VSS sg13cmos5l_tielo
Xbank_B_sram.gen_ihp_256x32.u_sram_256x32_1154 bank_B_sram.gen_ihp_256x32.u_sram_256x32_1154/L_LO
+ VDD VSS sg13cmos5l_tielo
Xbank_B_sram.gen_ihp_256x32.u_sram_256x32_1165 bank_B_sram.gen_ihp_256x32.u_sram_256x32_1165/L_LO
+ VDD VSS sg13cmos5l_tielo
X_6029_ _6049_/A _6056_/S _6029_/B VDD VSS sg13cmos5l_xnor2_1
XFILLER_73_148 VDD VSS sg13cmos5l_decap_4
XFILLER_55_874 VDD VSS sg13cmos5l_decap_8
XFILLER_64_69 VDD VSS sg13cmos5l_decap_4
XFILLER_82_671 VDD VSS sg13cmos5l_decap_8
XFILLER_54_384 VDD VSS sg13cmos5l_fill_1
XFILLER_70_833 VDD VSS sg13cmos5l_decap_8
XFILLER_81_170 VDD VSS sg13cmos5l_fill_1
XFILLER_49_134 VDD VSS sg13cmos5l_decap_4
XFILLER_64_115 VDD VSS sg13cmos5l_fill_2
XFILLER_65_616 VDD VSS sg13cmos5l_decap_4
XFILLER_65_649 VDD VSS sg13cmos5l_fill_2
XFILLER_46_841 VDD VSS sg13cmos5l_decap_8
XFILLER_61_800 VDD VSS sg13cmos5l_fill_2
XFILLER_61_844 VDD VSS sg13cmos5l_decap_8
XFILLER_73_682 VDD VSS sg13cmos5l_decap_4
XFILLER_60_387 VDD VSS sg13cmos5l_fill_2
X_6380_ _6380_/Y _6380_/A _6379_/A VDD VSS sg13cmos5l_nor2b_2
X_5400_ _5453_/B _5586_/A _5400_/B VDD VSS sg13cmos5l_xnor2_1
X_5331_ _5341_/A _5757_/A _5331_/B VDD VSS sg13cmos5l_xnor2_1
XFILLER_88_708 VDD VSS sg13cmos5l_fill_2
X_7001_ _7001_/Y _7001_/A VDD VSS sg13cmos5l_inv_1
X_5262_ _5263_/B _5684_/B1 _5385_/A2 _5622_/B1 _5385_/B2 VDD VSS sg13cmos5l_a22oi_1
X_5193_ _5194_/B _5622_/B1 _5385_/A2 _5193_/B1 _5385_/B2 VDD VSS sg13cmos5l_a22oi_1
X_4213_ _4226_/A _4213_/A1 _4178_/A _4212_/Y VDD VSS sg13cmos5l_a21oi_1
XFILLER_68_465 VDD VSS sg13cmos5l_fill_2
X_4144_ _7667_/D _4144_/A _4144_/B VDD VSS sg13cmos5l_xor2_1
XFILLER_56_627 VDD VSS sg13cmos5l_decap_8
XFILLER_56_649 VDD VSS sg13cmos5l_decap_8
XFILLER_55_159 VDD VSS sg13cmos5l_decap_4
XFILLER_64_660 VDD VSS sg13cmos5l_decap_4
XFILLER_70_129 VDD VSS sg13cmos5l_decap_8
XFILLER_52_866 VDD VSS sg13cmos5l_decap_8
XFILLER_51_376 VDD VSS sg13cmos5l_decap_4
X_6716_ _6896_/A _6716_/A _6716_/B VDD VSS sg13cmos5l_xor2_1
X_4977_ _7681_/D _4977_/A _4977_/B VDD VSS sg13cmos5l_xnor2_1
X_7696_ _7696_/Q clkload7/A _7696_/D place751/X VDD VSS sg13cmos5l_dfrbpq_1
Xclkload5 clkload5/Y clkload5/A VDD VSS sg13cmos5l_inv_1
X_3928_ _3955_/A quant_cfg[0] VDD VSS sg13cmos5l_buf_1
XFILLER_50_38 VDD VSS sg13cmos5l_decap_8
X_6647_ _6656_/A _6647_/A _6647_/B _6647_/C VDD VSS sg13cmos5l_and3_1
X_6578_ _6578_/Y _6579_/B _6579_/A VDD VSS sg13cmos5l_nor2_1
X_5529_ _5533_/A _5595_/B _5529_/B VDD VSS sg13cmos5l_xnor2_1
XFILLER_59_58 VDD VSS sg13cmos5l_decap_4
XFILLER_115_20 VDD VSS sg13cmos5l_fill_1
XFILLER_87_752 VDD VSS sg13cmos5l_decap_8
XFILLER_46_104 VDD VSS sg13cmos5l_fill_2
XFILLER_59_498 VDD VSS sg13cmos5l_fill_2
XFILLER_86_262 VDD VSS sg13cmos5l_fill_1
XFILLER_75_46 VDD VSS sg13cmos5l_decap_8
XFILLER_74_468 VDD VSS sg13cmos5l_decap_8
XFILLER_74_479 VDD VSS sg13cmos5l_fill_1
XFILLER_42_310 VDD VSS sg13cmos5l_fill_1
XFILLER_43_822 VDD VSS sg13cmos5l_decap_8
XFILLER_43_899 VDD VSS sg13cmos5l_decap_8
XFILLER_70_685 VDD VSS sg13cmos5l_fill_2
XFILLER_40_93 VDD VSS sg13cmos5l_fill_2
XFILLER_38_605 VDD VSS sg13cmos5l_decap_8
XFILLER_37_126 VDD VSS sg13cmos5l_decap_4
XFILLER_65_446 VDD VSS sg13cmos5l_decap_8
XFILLER_65_457 VDD VSS sg13cmos5l_fill_2
XFILLER_77_284 VDD VSS sg13cmos5l_fill_1
XFILLER_65_479 VDD VSS sg13cmos5l_fill_1
XFILLER_81_917 VDD VSS sg13cmos5l_fill_1
XFILLER_80_416 VDD VSS sg13cmos5l_decap_8
XFILLER_80_405 VDD VSS sg13cmos5l_decap_8
XFILLER_45_181 VDD VSS sg13cmos5l_decap_8
X_5880_ _5922_/A _5923_/B _5923_/A VDD VSS sg13cmos5l_xor2_1
X_4900_ _4902_/A _4836_/B _4900_/B VDD VSS sg13cmos5l_nand2b_1
XFILLER_61_652 VDD VSS sg13cmos5l_decap_8
XFILLER_61_663 VDD VSS sg13cmos5l_fill_1
X_4831_ _4832_/B _4882_/A _4882_/B VDD VSS sg13cmos5l_xor2_1
X_7550_ _7552_/A _7550_/A _7550_/B VDD VSS sg13cmos5l_nand2_1
X_4762_ _4763_/B _4820_/B1 _5009_/A2 _4762_/B1 _5140_/B2 VDD VSS sg13cmos5l_a22oi_1
X_7481_ _7484_/C _7603_/B _7603_/A VDD VSS sg13cmos5l_nand2_1
X_6501_ _6503_/A _6502_/A _6502_/C _7683_/Q VDD VSS sg13cmos5l_a21oi_1
X_4693_ _4694_/B _4742_/A _4742_/B VDD VSS sg13cmos5l_xor2_1
X_6432_ _6442_/A _6441_/B VDD VSS sg13cmos5l_inv_1
XFILLER_20_19 VDD VSS sg13cmos5l_fill_2
X_6363_ _6364_/A _6812_/B _6812_/A VDD VSS sg13cmos5l_nand2_2
Xmax_cap976 _4127_/A wire977/X VDD VSS sg13cmos5l_buf_8
Xmax_cap987 _5705_/A output893/A VDD VSS sg13cmos5l_buf_2
Xmax_cap998 _4946_/A _5322_/A1 VDD VSS sg13cmos5l_buf_2
X_6294_ _6294_/Y _6295_/B _6295_/A VDD VSS sg13cmos5l_nor2_1
X_5314_ _5314_/X _5314_/A _5314_/B VDD VSS sg13cmos5l_and2_1
XFILLER_88_527 VDD VSS sg13cmos5l_decap_4
X_5176_ _5221_/A _5126_/B _5126_/A _5175_/Y VDD VSS sg13cmos5l_a21oi_1
X_4127_ _4128_/C _4127_/A VDD VSS sg13cmos5l_inv_1
XFILLER_84_744 VDD VSS sg13cmos5l_decap_8
XFILLER_56_479 VDD VSS sg13cmos5l_decap_8
XFILLER_71_405 VDD VSS sg13cmos5l_decap_4
X_4058_ _4058_/Y _4058_/A _4058_/B VDD VSS sg13cmos5l_nor2_1
XFILLER_52_641 VDD VSS sg13cmos5l_fill_1
XFILLER_52_652 VDD VSS sg13cmos5l_decap_8
XFILLER_40_858 VDD VSS sg13cmos5l_decap_8
XFILLER_61_37 VDD VSS sg13cmos5l_fill_1
X_7679_ _7679_/Q _7679_/CLK _7679_/D place748/X VDD VSS sg13cmos5l_dfrbpq_1
XFILLER_117_4 VDD VSS sg13cmos5l_decap_8
Xinput800 _6199_/B bank_B_addr[4] VDD VSS sg13cmos5l_buf_1
Xinput811 input811/X bank_B_wdata[16] VDD VSS sg13cmos5l_buf_1
Xinput822 input822/X bank_B_wdata[26] VDD VSS sg13cmos5l_buf_1
Xinput833 input833/X bank_B_wdata[7] VDD VSS sg13cmos5l_buf_1
Xinput844 _7709_/D quant_cfg[18] VDD VSS sg13cmos5l_buf_1
Xinput855 _7720_/D quant_cfg[29] VDD VSS sg13cmos5l_buf_1
XFILLER_47_446 VDD VSS sg13cmos5l_decap_8
XFILLER_62_405 VDD VSS sg13cmos5l_fill_1
XFILLER_63_917 VDD VSS sg13cmos5l_fill_1
X_5030_ _5030_/X _5030_/A _5030_/B VDD VSS sg13cmos5l_and2_1
XFILLER_66_700 VDD VSS sg13cmos5l_decap_8
XFILLER_78_571 VDD VSS sg13cmos5l_fill_1
XFILLER_65_221 VDD VSS sg13cmos5l_fill_2
XFILLER_54_917 VDD VSS sg13cmos5l_fill_1
XFILLER_65_243 VDD VSS sg13cmos5l_decap_8
XFILLER_66_766 VDD VSS sg13cmos5l_decap_8
X_6981_ _6982_/B _6981_/A _6981_/B VDD VSS sg13cmos5l_nor2_1
XFILLER_81_714 VDD VSS sg13cmos5l_decap_8
X_5932_ _5935_/A _5936_/C _5971_/B VDD VSS sg13cmos5l_nand2_1
XFILLER_80_224 VDD VSS sg13cmos5l_decap_8
XFILLER_61_460 VDD VSS sg13cmos5l_fill_2
X_5863_ _5863_/X _5863_/A _5863_/B VDD VSS sg13cmos5l_and2_1
X_7602_ _7608_/A _7602_/A _7601_/Y VDD VSS sg13cmos5l_nor2b_2
X_5794_ _5795_/B _5949_/B1 _6084_/A2 _5909_/B1 _6084_/B2 VDD VSS sg13cmos5l_a22oi_1
X_4814_ _4815_/B _5244_/B1 _4878_/A2 _4814_/B1 _4878_/B2 VDD VSS sg13cmos5l_a22oi_1
X_7533_ _7615_/B _7533_/A _7533_/B VDD VSS sg13cmos5l_xor2_1
X_4745_ _4837_/B _4745_/A _4745_/B VDD VSS sg13cmos5l_xor2_1
X_7464_ _7597_/B _7464_/A _7585_/A VDD VSS sg13cmos5l_nand2_1
X_7395_ _7410_/A _7376_/A _7289_/B _7394_/Y VDD VSS sg13cmos5l_o21ai_1
X_6415_ _6435_/B _7674_/Q VDD VSS sg13cmos5l_inv_1
X_6346_ _6368_/B _6346_/A _6347_/A VDD VSS sg13cmos5l_nor2b_2
XFILLER_88_313 VDD VSS sg13cmos5l_decap_8
X_6277_ _6611_/B _6277_/A _6277_/B VDD VSS sg13cmos5l_and2_2
X_5228_ _5230_/A _5228_/A VDD VSS sg13cmos5l_inv_1
XFILLER_57_744 VDD VSS sg13cmos5l_decap_8
XFILLER_57_755 VDD VSS sg13cmos5l_fill_2
X_5159_ _5160_/B _5157_/Y _5090_/B _5158_/Y VDD VSS sg13cmos5l_o21ai_1
XFILLER_57_777 VDD VSS sg13cmos5l_fill_2
XFILLER_72_747 VDD VSS sg13cmos5l_fill_2
XFILLER_60_909 VDD VSS sg13cmos5l_decap_8
XFILLER_71_279 VDD VSS sg13cmos5l_fill_1
XFILLER_80_780 VDD VSS sg13cmos5l_decap_8
Xclkbuf_4_4_0_clk_i_regs _7720_/CLK clkbuf_0_clk_i_regs/X VDD VSS sg13cmos5l_buf_8
XFILLER_48_700 VDD VSS sg13cmos5l_fill_1
XFILLER_47_210 VDD VSS sg13cmos5l_decap_8
XFILLER_48_744 VDD VSS sg13cmos5l_fill_2
Xplace703 _7046_/B _7004_/A VDD VSS sg13cmos5l_buf_1
Xplace714 _6974_/B _6957_/S VDD VSS sg13cmos5l_buf_1
XFILLER_51_909 VDD VSS sg13cmos5l_decap_8
XFILLER_62_235 VDD VSS sg13cmos5l_fill_1
Xplace725 _5747_/A _6110_/B VDD VSS sg13cmos5l_buf_1
Xplace736 _4947_/A _5335_/A VDD VSS sg13cmos5l_buf_1
Xplace747 place747/X place748/X VDD VSS sg13cmos5l_buf_1
XFILLER_50_419 VDD VSS sg13cmos5l_decap_4
XFILLER_62_268 VDD VSS sg13cmos5l_fill_1
XFILLER_62_91 VDD VSS sg13cmos5l_fill_1
X_4461_ _4461_/X _4461_/A _4461_/B VDD VSS sg13cmos5l_and2_1
Xrebuffer2006 _4230_/A rebuffer2007/X VDD VSS sg13cmos5l_buf_1
Xrebuffer2028 _6565_/C _6251_/A VDD VSS sg13cmos5l_buf_1
X_7180_ _7183_/A _7178_/X _7233_/B VDD VSS sg13cmos5l_nand2b_1
X_6200_ _6200_/Y _6209_/A1 _6198_/Y _6199_/Y VDD VSS sg13cmos5l_a21oi_1
Xrebuffer1305 rebuffer1305/X rebuffer1306/X VDD VSS sg13cmos5l_buf_1
Xrebuffer2039 _7319_/B _6954_/Y VDD VSS sg13cmos5l_buf_1
Xrebuffer1316 rebuffer1316/X rebuffer1317/X VDD VSS sg13cmos5l_buf_1
X_6131_ _6134_/A _6155_/B _6155_/A VDD VSS sg13cmos5l_xor2_1
X_4392_ _4440_/A _4525_/B _4326_/A _4391_/Y VDD VSS sg13cmos5l_a21o_1
Xrebuffer1349 rebuffer1349/X rebuffer1350/X VDD VSS sg13cmos5l_buf_1
Xrebuffer1338 rebuffer1338/X _7348_/A VDD VSS sg13cmos5l_buf_1
Xrebuffer1327 _6266_/A _6268_/A VDD VSS sg13cmos5l_buf_1
X_6062_ _6079_/A _6062_/A _6062_/B VDD VSS sg13cmos5l_xnor2_1
XFILLER_38_221 VDD VSS sg13cmos5l_fill_1
X_5013_ _5014_/C _5013_/A VDD VSS sg13cmos5l_inv_1
XFILLER_38_276 VDD VSS sg13cmos5l_fill_2
XFILLER_38_298 VDD VSS sg13cmos5l_fill_2
XFILLER_39_799 VDD VSS sg13cmos5l_decap_8
XFILLER_53_224 VDD VSS sg13cmos5l_fill_2
X_6964_ _7142_/A _6961_/Y _7087_/B _7018_/B VDD VSS sg13cmos5l_mux2_1
X_6895_ _6987_/A _7611_/B _7713_/Q VDD VSS sg13cmos5l_nor2b_2
X_5915_ _5916_/B _5915_/A _5939_/A VDD VSS sg13cmos5l_xnor2_1
XFILLER_81_588 VDD VSS sg13cmos5l_decap_8
XFILLER_81_577 VDD VSS sg13cmos5l_fill_2
XFILLER_42_17 VDD VSS sg13cmos5l_fill_1
XFILLER_62_791 VDD VSS sg13cmos5l_decap_8
X_5846_ _5847_/B _5846_/A _5848_/B VDD VSS sg13cmos5l_nand2_1
X_5777_ _5835_/B _5726_/B _5775_/Y _5776_/Y VDD VSS sg13cmos5l_a21oi_1
X_7516_ _7516_/Y _7516_/A1 _7518_/A _7355_/B VDD VSS sg13cmos5l_a21oi_1
X_4728_ _4729_/B _4726_/X _4728_/B VDD VSS sg13cmos5l_nand2b_1
X_7447_ _7589_/A _7447_/A VDD VSS sg13cmos5l_inv_1
X_4659_ _4660_/B _4602_/B _4602_/A _4658_/X VDD VSS sg13cmos5l_a21o_1
X_7378_ _7385_/A _7289_/A _7234_/Y _7377_/Y VDD VSS sg13cmos5l_o21ai_1
X_6329_ _6330_/B _6329_/A _6331_/B VDD VSS sg13cmos5l_nor2b_2
XFILLER_88_121 VDD VSS sg13cmos5l_fill_1
Xrebuffer1872 _4065_/B _4064_/Y VDD VSS sg13cmos5l_buf_1
XFILLER_57_530 VDD VSS sg13cmos5l_decap_8
Xrebuffer1894 _5616_/A rebuffer1926/X VDD VSS sg13cmos5l_buf_1
Xrebuffer1883 _4913_/B _4975_/A VDD VSS sg13cmos5l_buf_1
XFILLER_88_187 VDD VSS sg13cmos5l_decap_4
XFILLER_123_20 VDD VSS sg13cmos5l_fill_1
XFILLER_57_563 VDD VSS sg13cmos5l_decap_4
XFILLER_84_382 VDD VSS sg13cmos5l_decap_8
XFILLER_44_246 VDD VSS sg13cmos5l_decap_8
XFILLER_72_577 VDD VSS sg13cmos5l_fill_1
XFILLER_72_588 VDD VSS sg13cmos5l_fill_2
XFILLER_53_780 VDD VSS sg13cmos5l_fill_1
XFILLER_68_817 VDD VSS sg13cmos5l_decap_8
XFILLER_79_165 VDD VSS sg13cmos5l_decap_8
XFILLER_79_176 VDD VSS sg13cmos5l_fill_1
XFILLER_82_308 VDD VSS sg13cmos5l_decap_8
XFILLER_76_861 VDD VSS sg13cmos5l_decap_8
XFILLER_82_319 VDD VSS sg13cmos5l_decap_8
Xplace511 _7377_/B _7328_/B VDD VSS sg13cmos5l_buf_1
Xplace522 _6450_/A2 _6381_/B1 VDD VSS sg13cmos5l_buf_4
Xplace533 _5493_/A2 _5050_/A2 VDD VSS sg13cmos5l_buf_1
Xplace544 _5246_/B2 _5687_/B2 VDD VSS sg13cmos5l_buf_1
Xplace555 _5322_/B2 _4753_/B2 VDD VSS sg13cmos5l_buf_1
Xplace566 _5585_/B2 _3979_/Y VDD VSS sg13cmos5l_buf_1
Xplace577 _7380_/B _7331_/B VDD VSS sg13cmos5l_buf_1
Xplace588 _7111_/A _6698_/A VDD VSS sg13cmos5l_buf_1
Xplace599 _4303_/A _5179_/A2 VDD VSS sg13cmos5l_buf_1
X_5700_ _5749_/A _5870_/A _5700_/B VDD VSS sg13cmos5l_xnor2_1
XFILLER_43_290 VDD VSS sg13cmos5l_fill_1
X_6680_ _6680_/Y _6681_/A _6681_/C _6681_/B VDD VSS sg13cmos5l_a21oi_1
X_5631_ _5632_/B _5909_/B1 _6021_/A2 _5859_/B1 _6021_/B2 VDD VSS sg13cmos5l_a22oi_1
X_5562_ _5619_/A _5511_/B _5511_/A _5561_/X VDD VSS sg13cmos5l_a21oi_1
X_7301_ _7301_/X _7300_/Y _7301_/A2 _7059_/Y VDD VSS sg13cmos5l_a21o_1
X_4513_ _4568_/A _4871_/A _4513_/B VDD VSS sg13cmos5l_xnor2_1
Xoutput901 bank_B_rdata[0] _6213_/B VDD VSS sg13cmos5l_buf_1
Xoutput912 bank_B_rdata[1] _6215_/B VDD VSS sg13cmos5l_buf_1
X_7232_ _7245_/A _7232_/A _7531_/A _7532_/B VDD VSS sg13cmos5l_nand3_1
X_5493_ _5556_/S _5557_/B1 _5493_/A2 _5493_/B1 _4496_/Y VDD VSS sg13cmos5l_a22oi_1
Xoutput923 bank_B_rdata[2] _6217_/B VDD VSS sg13cmos5l_buf_1
X_7163_ _7167_/A _7163_/A _7246_/A _7163_/C VDD VSS sg13cmos5l_nand3_1
XFILLER_59_828 VDD VSS sg13cmos5l_decap_8
X_7094_ _7122_/B _7060_/Y _7094_/B VDD VSS sg13cmos5l_nand2b_1
X_6114_ _6114_/Y _6136_/A _6114_/B VDD VSS sg13cmos5l_nand2_1
X_6045_ _6047_/A _6046_/A _6046_/B _6046_/C VDD VSS sg13cmos5l_a21oi_1
XFILLER_86_647 VDD VSS sg13cmos5l_decap_8
XFILLER_37_17 VDD VSS sg13cmos5l_fill_1
XFILLER_85_157 VDD VSS sg13cmos5l_fill_2
XFILLER_39_585 VDD VSS sg13cmos5l_fill_1
XFILLER_54_544 VDD VSS sg13cmos5l_decap_8
XFILLER_82_853 VDD VSS sg13cmos5l_decap_8
XFILLER_42_728 VDD VSS sg13cmos5l_fill_2
X_6947_ _6947_/X _6947_/A _6968_/B VDD VSS sg13cmos5l_and2_1
XFILLER_41_249 VDD VSS sg13cmos5l_fill_1
X_6878_ _6878_/Y _6878_/A1 _6836_/B _6505_/B VDD VSS sg13cmos5l_a21oi_1
X_5829_ _5830_/A _5829_/A _5829_/B VDD VSS sg13cmos5l_nand2_1
XFILLER_77_614 VDD VSS sg13cmos5l_decap_8
XFILLER_76_146 VDD VSS sg13cmos5l_fill_1
XFILLER_45_533 VDD VSS sg13cmos5l_decap_8
XFILLER_73_831 VDD VSS sg13cmos5l_decap_8
XFILLER_72_341 VDD VSS sg13cmos5l_decap_4
XFILLER_41_761 VDD VSS sg13cmos5l_decap_8
XFILLER_60_558 VDD VSS sg13cmos5l_decap_8
X_4160_ _4160_/Y _5977_/B _5977_/A _4159_/Y VDD VSS sg13cmos5l_o21ai_1
XFILLER_49_850 VDD VSS sg13cmos5l_decap_8
XFILLER_67_157 VDD VSS sg13cmos5l_decap_8
X_4091_ _4092_/B _4091_/A _4120_/A VDD VSS sg13cmos5l_xor2_1
XFILLER_48_371 VDD VSS sg13cmos5l_fill_1
XFILLER_83_628 VDD VSS sg13cmos5l_decap_8
XFILLER_82_116 VDD VSS sg13cmos5l_fill_2
XFILLER_64_897 VDD VSS sg13cmos5l_decap_8
X_6801_ _6801_/Y _6798_/Y _6800_/A _6800_/Y VDD VSS sg13cmos5l_a21oi_1
X_4993_ _5091_/A _4993_/A _4993_/B VDD VSS sg13cmos5l_xor2_1
XFILLER_23_19 VDD VSS sg13cmos5l_fill_2
X_6732_ _6732_/Y _6732_/A _6732_/B VDD VSS sg13cmos5l_xnor2_1
X_3944_ _7660_/D _3953_/A _3944_/B VDD VSS sg13cmos5l_xor2_1
XFILLER_90_0 VDD VSS sg13cmos5l_fill_1
X_6663_ _6665_/A _6688_/A _6663_/B VDD VSS sg13cmos5l_nand2_1
X_5614_ _5617_/A _5618_/C _5674_/B VDD VSS sg13cmos5l_nand2_1
X_6594_ _6600_/A _6594_/A _6594_/B VDD VSS sg13cmos5l_nand2_2
X_5545_ _5546_/B _5545_/A _5544_/Y VDD VSS sg13cmos5l_nor2b_1
X_5476_ _5479_/A _5542_/B _5542_/A VDD VSS sg13cmos5l_xor2_1
X_7215_ _7331_/B _7720_/Q VDD VSS sg13cmos5l_inv_1
X_4427_ _4486_/A _4381_/B _4381_/A _4426_/X VDD VSS sg13cmos5l_a21o_1
Xbank_A_sram.gen_ihp_256x32.u_sram_256x32_1179 bank_A_sram.gen_ihp_256x32.u_sram_256x32/A_BM[4]
+ VDD VSS sg13cmos5l_tiehi
X_7146_ _7147_/B _7299_/A1 _7137_/Y _7145_/Y VDD VSS sg13cmos5l_o21ai_1
XFILLER_59_636 VDD VSS sg13cmos5l_fill_2
X_4358_ _4467_/B _4358_/A _4358_/B VDD VSS sg13cmos5l_nor2_1
XFILLER_58_135 VDD VSS sg13cmos5l_decap_8
Xbank_B_sram.gen_ihp_256x32.u_sram_256x32_1100 bank_B_sram.gen_ihp_256x32.u_sram_256x32_1100/L_LO
+ VDD VSS sg13cmos5l_tielo
Xbank_B_sram.gen_ihp_256x32.u_sram_256x32_1111 bank_B_sram.gen_ihp_256x32.u_sram_256x32_1111/L_LO
+ VDD VSS sg13cmos5l_tielo
Xbank_B_sram.gen_ihp_256x32.u_sram_256x32_1122 bank_B_sram.gen_ihp_256x32.u_sram_256x32_1122/L_LO
+ VDD VSS sg13cmos5l_tielo
X_7077_ _7077_/Y _7277_/B _7068_/Y _7076_/Y VDD VSS sg13cmos5l_o21ai_1
X_4289_ _4290_/B _4289_/A _4289_/B VDD VSS sg13cmos5l_xor2_1
XFILLER_86_444 VDD VSS sg13cmos5l_fill_1
Xbank_B_sram.gen_ihp_256x32.u_sram_256x32_1133 bank_B_sram.gen_ihp_256x32.u_sram_256x32_1133/L_LO
+ VDD VSS sg13cmos5l_tielo
Xbank_B_sram.gen_ihp_256x32.u_sram_256x32_1144 bank_B_sram.gen_ihp_256x32.u_sram_256x32_1144/L_LO
+ VDD VSS sg13cmos5l_tielo
Xbank_B_sram.gen_ihp_256x32.u_sram_256x32_1155 bank_B_sram.gen_ihp_256x32.u_sram_256x32_1155/L_LO
+ VDD VSS sg13cmos5l_tielo
X_6028_ _6029_/B _6085_/A _6028_/B VDD VSS sg13cmos5l_xnor2_1
XFILLER_55_853 VDD VSS sg13cmos5l_decap_8
XFILLER_64_26 VDD VSS sg13cmos5l_decap_8
Xbank_B_sram.gen_ihp_256x32.u_sram_256x32_1166 bank_B_sram.gen_ihp_256x32.u_sram_256x32_1166/L_LO
+ VDD VSS sg13cmos5l_tielo
XFILLER_54_363 VDD VSS sg13cmos5l_fill_1
XFILLER_70_812 VDD VSS sg13cmos5l_decap_8
XFILLER_82_650 VDD VSS sg13cmos5l_decap_8
XFILLER_42_558 VDD VSS sg13cmos5l_decap_4
XFILLER_70_889 VDD VSS sg13cmos5l_decap_8
Xdelaybuf_0_clk_i clkbuf_0_clk_i/A clk_i VDD VSS sg13cmos5l_buf_16
XFILLER_78_912 VDD VSS sg13cmos5l_decap_4
XFILLER_65_606 VDD VSS sg13cmos5l_fill_1
XFILLER_37_308 VDD VSS sg13cmos5l_fill_1
XFILLER_46_820 VDD VSS sg13cmos5l_decap_8
XFILLER_45_341 VDD VSS sg13cmos5l_decap_8
XFILLER_45_363 VDD VSS sg13cmos5l_fill_1
XFILLER_73_661 VDD VSS sg13cmos5l_decap_8
XFILLER_46_897 VDD VSS sg13cmos5l_decap_8
XFILLER_61_823 VDD VSS sg13cmos5l_decap_8
XFILLER_54_81 VDD VSS sg13cmos5l_fill_1
XFILLER_54_92 VDD VSS sg13cmos5l_fill_2
XFILLER_70_80 VDD VSS sg13cmos5l_decap_8
X_5330_ _5331_/B _5076_/A _5514_/A2 _5013_/A _5756_/B2 VDD VSS sg13cmos5l_a22oi_1
X_5261_ _5314_/A _5442_/A _5261_/B VDD VSS sg13cmos5l_xnor2_1
X_7000_ _7326_/A _7233_/A _7109_/A _7233_/C VDD VSS sg13cmos5l_nand3_1
X_4212_ _4212_/Y _4212_/A _4212_/B VDD VSS sg13cmos5l_nor2_1
X_5192_ _5249_/A _5192_/A _5192_/B VDD VSS sg13cmos5l_xnor2_1
XFILLER_68_433 VDD VSS sg13cmos5l_decap_4
X_4143_ _4143_/Y _4143_/A _4143_/B VDD VSS sg13cmos5l_xnor2_1
XFILLER_18_19 VDD VSS sg13cmos5l_fill_2
X_4074_ _4074_/Y _4207_/A _5897_/A _4073_/Y VDD VSS sg13cmos5l_o21ai_1
XFILLER_49_691 VDD VSS sg13cmos5l_decap_4
XFILLER_37_886 VDD VSS sg13cmos5l_fill_1
XFILLER_70_108 VDD VSS sg13cmos5l_fill_1
XFILLER_51_322 VDD VSS sg13cmos5l_decap_8
XFILLER_52_845 VDD VSS sg13cmos5l_decap_8
XFILLER_51_355 VDD VSS sg13cmos5l_fill_1
X_4976_ _4977_/B _4974_/X _4976_/B VDD VSS sg13cmos5l_nand2b_1
X_7695_ _7695_/Q clkload7/A _7695_/D place751/X VDD VSS sg13cmos5l_dfrbpq_1
X_3927_ _3927_/Y _3927_/A VDD VSS sg13cmos5l_inv_1
Xclkbuf_4_9_0_clk_i_regs clkload5/A clkbuf_0_clk_i_regs/X VDD VSS sg13cmos5l_buf_8
Xclkload6 clkload6/Y clkload6/A VDD VSS sg13cmos5l_inv_1
X_6646_ _6646_/Y _6647_/A _6647_/C _6647_/B VDD VSS sg13cmos5l_a21oi_1
X_6577_ _6579_/B _6611_/A _6577_/B VDD VSS sg13cmos5l_nand2_1
X_5528_ _5529_/B _5528_/A _5596_/B VDD VSS sg13cmos5l_xor2_1
XFILLER_59_48 VDD VSS sg13cmos5l_fill_2
X_5459_ _5460_/C _5459_/A VDD VSS sg13cmos5l_inv_1
XFILLER_79_709 VDD VSS sg13cmos5l_decap_8
XFILLER_87_731 VDD VSS sg13cmos5l_decap_8
X_7129_ _7129_/Y _7246_/A _7129_/B VDD VSS sg13cmos5l_nor2_1
XFILLER_86_241 VDD VSS sg13cmos5l_fill_2
XFILLER_47_628 VDD VSS sg13cmos5l_fill_1
XFILLER_59_477 VDD VSS sg13cmos5l_fill_2
XFILLER_75_36 VDD VSS sg13cmos5l_fill_2
XFILLER_43_801 VDD VSS sg13cmos5l_decap_8
XFILLER_42_333 VDD VSS sg13cmos5l_fill_2
XFILLER_43_878 VDD VSS sg13cmos5l_decap_8
XFILLER_70_631 VDD VSS sg13cmos5l_fill_1
XFILLER_69_208 VDD VSS sg13cmos5l_decap_8
XFILLER_49_70 VDD VSS sg13cmos5l_decap_4
XFILLER_1_11 VDD VSS sg13cmos5l_decap_8
XFILLER_38_628 VDD VSS sg13cmos5l_decap_8
XFILLER_66_915 VDD VSS sg13cmos5l_fill_2
XFILLER_78_786 VDD VSS sg13cmos5l_decap_8
XFILLER_77_263 VDD VSS sg13cmos5l_decap_4
XFILLER_37_149 VDD VSS sg13cmos5l_decap_8
XFILLER_46_661 VDD VSS sg13cmos5l_decap_8
XFILLER_46_672 VDD VSS sg13cmos5l_fill_2
XFILLER_52_108 VDD VSS sg13cmos5l_decap_8
XFILLER_65_91 VDD VSS sg13cmos5l_fill_1
X_4830_ _4882_/B _5018_/A _4830_/B VDD VSS sg13cmos5l_xnor2_1
X_7480_ _7484_/A _7480_/A _7480_/B VDD VSS sg13cmos5l_nand2_2
X_6500_ _6502_/A _6508_/B _6508_/A VDD VSS sg13cmos5l_xnor2_1
X_4692_ _4742_/B _4692_/A _4692_/B VDD VSS sg13cmos5l_xnor2_1
X_6431_ _6441_/B _6431_/A _6431_/B VDD VSS sg13cmos5l_nand2_2
X_6362_ _6812_/A _6362_/A _6364_/B VDD VSS sg13cmos5l_nor2b_2
X_5313_ _5366_/A _5368_/A _5368_/B VDD VSS sg13cmos5l_xor2_1
X_6293_ _6295_/A _6293_/A _6293_/B VDD VSS sg13cmos5l_nor2_2
X_5244_ _5307_/A _5310_/B1 _5493_/A2 _5244_/B1 _5370_/B2 VDD VSS sg13cmos5l_a22oi_1
XFILLER_69_742 VDD VSS sg13cmos5l_fill_1
X_5175_ _5175_/Y _5175_/A _5125_/A VDD VSS sg13cmos5l_nor2b_1
XFILLER_56_414 VDD VSS sg13cmos5l_fill_2
XFILLER_68_252 VDD VSS sg13cmos5l_decap_8
XFILLER_68_263 VDD VSS sg13cmos5l_fill_2
X_4126_ _4129_/A _3955_/A _4127_/A _3960_/Y VDD VSS sg13cmos5l_a21oi_1
XFILLER_84_723 VDD VSS sg13cmos5l_decap_8
XFILLER_83_211 VDD VSS sg13cmos5l_decap_4
XFILLER_37_661 VDD VSS sg13cmos5l_fill_1
XFILLER_72_907 VDD VSS sg13cmos5l_decap_8
X_4057_ _4058_/B _4172_/A _4086_/B _4057_/C VDD VSS sg13cmos5l_nor3_1
XFILLER_52_620 VDD VSS sg13cmos5l_fill_2
XFILLER_101_12 VDD VSS sg13cmos5l_fill_1
XFILLER_40_837 VDD VSS sg13cmos5l_decap_8
X_4959_ _4959_/Y _4898_/A _4959_/B VDD VSS sg13cmos5l_nand2b_1
X_7678_ _7678_/Q _7679_/CLK _7678_/D place747/X VDD VSS sg13cmos5l_dfrbpq_1
X_6629_ _6754_/B _6629_/A _6629_/B VDD VSS sg13cmos5l_nand2_2
XFILLER_79_506 VDD VSS sg13cmos5l_decap_4
Xinput801 _6202_/B bank_B_addr[5] VDD VSS sg13cmos5l_buf_1
Xinput812 input812/X bank_B_wdata[17] VDD VSS sg13cmos5l_buf_1
XFILLER_86_35 VDD VSS sg13cmos5l_fill_1
XFILLER_59_252 VDD VSS sg13cmos5l_fill_2
Xinput823 input823/X bank_B_wdata[27] VDD VSS sg13cmos5l_buf_1
Xinput834 input834/X bank_B_wdata[8] VDD VSS sg13cmos5l_buf_1
Xinput845 _7710_/D quant_cfg[19] VDD VSS sg13cmos5l_buf_1
Xinput856 _3946_/B quant_cfg[2] VDD VSS sg13cmos5l_buf_1
XFILLER_87_561 VDD VSS sg13cmos5l_fill_1
XFILLER_59_285 VDD VSS sg13cmos5l_decap_4
XFILLER_74_211 VDD VSS sg13cmos5l_decap_8
XFILLER_74_222 VDD VSS sg13cmos5l_fill_2
XFILLER_62_439 VDD VSS sg13cmos5l_decap_8
XFILLER_51_60 VDD VSS sg13cmos5l_decap_8
XFILLER_51_82 VDD VSS sg13cmos5l_fill_2
XFILLER_39_904 VDD VSS sg13cmos5l_decap_8
XFILLER_66_723 VDD VSS sg13cmos5l_fill_1
XFILLER_53_406 VDD VSS sg13cmos5l_decap_8
XFILLER_65_233 VDD VSS sg13cmos5l_decap_4
XFILLER_66_789 VDD VSS sg13cmos5l_fill_2
X_6980_ _6981_/B _7187_/A _6973_/Y _6979_/Y VDD VSS sg13cmos5l_o21ai_1
X_5931_ _5971_/B _5930_/B _5931_/B VDD VSS sg13cmos5l_nand2b_1
XFILLER_80_258 VDD VSS sg13cmos5l_decap_8
XFILLER_80_247 VDD VSS sg13cmos5l_fill_1
X_5862_ _5865_/A _5908_/S _5862_/B VDD VSS sg13cmos5l_xnor2_1
XFILLER_80_269 VDD VSS sg13cmos5l_fill_1
X_7601_ _7601_/Y _7629_/B _7601_/B VDD VSS sg13cmos5l_nor2_1
X_4813_ _4863_/A _4871_/A _4813_/B VDD VSS sg13cmos5l_xnor2_1
X_7532_ _7533_/B _7540_/B _7532_/B VDD VSS sg13cmos5l_nand2_1
X_4744_ _4745_/B _4744_/A _4796_/A VDD VSS sg13cmos5l_xnor2_1
X_7463_ _7464_/A _7472_/A1 _7253_/Y _7472_/B1 VDD VSS sg13cmos5l_o21ai_1
X_4675_ _4736_/S _4738_/B1 _5050_/A2 _4675_/B1 _4920_/B2 VDD VSS sg13cmos5l_a22oi_1
X_7394_ _7394_/Y _7284_/A _7405_/A2 _7377_/B VDD VSS sg13cmos5l_a21oi_1
X_6414_ _6821_/A _6414_/A _6823_/A VDD VSS sg13cmos5l_nand2_2
X_6345_ _6347_/A _6602_/A _6638_/B VDD VSS sg13cmos5l_nand2_1
X_5227_ _5232_/B _5227_/A _5227_/B VDD VSS sg13cmos5l_xnor2_1
XFILLER_88_336 VDD VSS sg13cmos5l_decap_8
XFILLER_56_16 VDD VSS sg13cmos5l_decap_8
X_5158_ _5158_/Y _5089_/A _5158_/B VDD VSS sg13cmos5l_nand2b_1
X_5089_ _5090_/B _5089_/A _5158_/B VDD VSS sg13cmos5l_xor2_1
X_4109_ _4145_/A _4109_/A _4109_/B VDD VSS sg13cmos5l_nand2_1
XFILLER_112_11 VDD VSS sg13cmos5l_decap_8
XFILLER_84_597 VDD VSS sg13cmos5l_decap_8
XFILLER_72_759 VDD VSS sg13cmos5l_fill_2
XFILLER_52_472 VDD VSS sg13cmos5l_fill_2
XFILLER_40_678 VDD VSS sg13cmos5l_decap_4
XFILLER_48_712 VDD VSS sg13cmos5l_decap_8
XFILLER_79_369 VDD VSS sg13cmos5l_decap_8
XFILLER_75_531 VDD VSS sg13cmos5l_fill_1
XFILLER_47_277 VDD VSS sg13cmos5l_decap_4
XFILLER_62_214 VDD VSS sg13cmos5l_fill_1
Xplace704 _7004_/A _7002_/B VDD VSS sg13cmos5l_buf_1
XFILLER_75_575 VDD VSS sg13cmos5l_decap_4
Xplace715 _6955_/B _6957_/S VDD VSS sg13cmos5l_buf_1
Xplace726 _5194_/A _4692_/A VDD VSS sg13cmos5l_buf_1
Xplace737 _5460_/A _5335_/A VDD VSS sg13cmos5l_buf_1
Xplace748 place748/X place750/X VDD VSS sg13cmos5l_buf_1
XFILLER_70_280 VDD VSS sg13cmos5l_fill_1
X_4460_ _4463_/A _4460_/A _4460_/B VDD VSS sg13cmos5l_xor2_1
Xrebuffer2007 rebuffer2007/X rebuffer2008/X VDD VSS sg13cmos5l_buf_1
X_4391_ _4391_/Y _4391_/A _4391_/B VDD VSS sg13cmos5l_nor2_1
Xrebuffer2029 _6429_/B _6251_/A VDD VSS sg13cmos5l_buf_1
Xrebuffer1317 rebuffer1317/X rebuffer1318/X VDD VSS sg13cmos5l_buf_1
Xrebuffer1306 rebuffer1306/X rebuffer1307/X VDD VSS sg13cmos5l_buf_1
X_6130_ _6155_/A _5966_/A _6099_/B _6129_/Y VDD VSS sg13cmos5l_o21ai_1
Xrebuffer1339 rebuffer1339/X rebuffer1340/X VDD VSS sg13cmos5l_buf_1
Xrebuffer1328 _6861_/A rebuffer1402/X VDD VSS sg13cmos5l_buf_1
X_6061_ _6062_/B _6081_/S _6061_/B VDD VSS sg13cmos5l_xnor2_1
XFILLER_86_829 VDD VSS sg13cmos5l_decap_8
X_5012_ _5015_/A _5012_/A1 _5013_/A _5012_/B1 VDD VSS sg13cmos5l_a21oi_1
XFILLER_39_778 VDD VSS sg13cmos5l_decap_8
XFILLER_54_704 VDD VSS sg13cmos5l_fill_2
XFILLER_38_266 VDD VSS sg13cmos5l_fill_2
XFILLER_54_726 VDD VSS sg13cmos5l_fill_1
XFILLER_81_512 VDD VSS sg13cmos5l_decap_4
X_6963_ _7087_/B _6826_/Y _6957_/S _6962_/X VDD VSS sg13cmos5l_a21oi_1
X_6894_ _7611_/B _6894_/A _6894_/B VDD VSS sg13cmos5l_nand2_2
X_5914_ _5939_/A _5874_/B _5874_/A _5913_/X VDD VSS sg13cmos5l_a21oi_1
X_5845_ _5848_/B _5845_/A _5845_/B VDD VSS sg13cmos5l_nand2_1
X_5776_ _5776_/Y _5776_/A _5776_/B VDD VSS sg13cmos5l_nor2_1
X_7515_ _7619_/A _7515_/A _7515_/B VDD VSS sg13cmos5l_xor2_1
X_4727_ _4728_/B _4727_/A _4727_/B VDD VSS sg13cmos5l_nand2_1
X_7446_ _7447_/A _7585_/A _7452_/A VDD VSS sg13cmos5l_nor2_1
X_4658_ _4658_/X _4658_/A _4658_/B VDD VSS sg13cmos5l_and2_1
X_7377_ _7377_/Y _7377_/A _7377_/B VDD VSS sg13cmos5l_nor2_1
X_4589_ _4590_/B _4947_/A _4767_/B _4589_/C VDD VSS sg13cmos5l_nor3_1
X_6328_ _6331_/B _6328_/A _7665_/Q _6328_/C VDD VSS sg13cmos5l_nand3_1
XFILLER_49_509 VDD VSS sg13cmos5l_fill_2
XFILLER_67_37 VDD VSS sg13cmos5l_fill_1
Xrebuffer1873 _4108_/A _4109_/A VDD VSS sg13cmos5l_buf_2
XFILLER_67_59 VDD VSS sg13cmos5l_fill_1
Xrebuffer1895 _6016_/A rebuffer1951/X VDD VSS sg13cmos5l_buf_1
Xrebuffer1884 _4295_/A _4291_/B VDD VSS sg13cmos5l_buf_1
XFILLER_45_726 VDD VSS sg13cmos5l_decap_8
XFILLER_85_884 VDD VSS sg13cmos5l_decap_8
XFILLER_44_269 VDD VSS sg13cmos5l_decap_8
XFILLER_60_707 VDD VSS sg13cmos5l_fill_1
XFILLER_60_729 VDD VSS sg13cmos5l_fill_2
XFILLER_53_792 VDD VSS sg13cmos5l_fill_1
XFILLER_40_464 VDD VSS sg13cmos5l_fill_2
XFILLER_40_497 VDD VSS sg13cmos5l_fill_1
XFILLER_79_111 VDD VSS sg13cmos5l_fill_1
XFILLER_67_317 VDD VSS sg13cmos5l_decap_8
XFILLER_67_339 VDD VSS sg13cmos5l_fill_2
XFILLER_48_553 VDD VSS sg13cmos5l_fill_2
XFILLER_76_840 VDD VSS sg13cmos5l_decap_8
Xplace512 _7328_/B _7274_/Y VDD VSS sg13cmos5l_buf_1
Xplace523 _6684_/C _6641_/C VDD VSS sg13cmos5l_buf_1
Xplace534 _5050_/A2 _4493_/Y VDD VSS sg13cmos5l_buf_1
Xplace545 _5687_/B2 _4365_/Y VDD VSS sg13cmos5l_buf_1
Xplace556 _4753_/B2 _4311_/B2 VDD VSS sg13cmos5l_buf_1
X_3960_ _3960_/Y _3960_/A VDD VSS sg13cmos5l_inv_1
XFILLER_44_792 VDD VSS sg13cmos5l_decap_8
Xplace567 _5017_/B2 _4531_/B2 VDD VSS sg13cmos5l_buf_1
Xplace578 _6918_/B _6927_/B VDD VSS sg13cmos5l_buf_1
Xplace589 _7233_/B _7294_/B VDD VSS sg13cmos5l_buf_1
X_5630_ _6052_/B _5630_/A VDD VSS sg13cmos5l_buf_1
X_5561_ _5561_/X _5561_/A _5561_/B VDD VSS sg13cmos5l_and2_1
X_7300_ _7300_/Y _7126_/Y _7233_/B _7182_/A VDD VSS sg13cmos5l_a21oi_1
X_5492_ _5500_/A _5433_/B _5302_/A _5492_/S VDD VSS sg13cmos5l_mux2_1
X_4512_ _4513_/B _5050_/B1 _4753_/A2 _4986_/B1 _4753_/B2 VDD VSS sg13cmos5l_a22oi_1
Xoutput902 bank_B_rdata[10] output902/A VDD VSS sg13cmos5l_buf_1
X_7231_ _7532_/B _7214_/B _7720_/Q VDD VSS sg13cmos5l_nand2b_1
Xoutput913 bank_B_rdata[20] wire973/X VDD VSS sg13cmos5l_buf_1
Xoutput924 bank_B_rdata[30] wire963/X VDD VSS sg13cmos5l_buf_1
X_4443_ _4453_/A _4643_/A _4443_/B VDD VSS sg13cmos5l_xnor2_1
X_7162_ _7163_/C _7162_/A _7162_/B _7162_/C VDD VSS sg13cmos5l_nand3_1
X_4374_ _4381_/A _4374_/A _4374_/B VDD VSS sg13cmos5l_xnor2_1
X_7093_ _7094_/B _7077_/Y _7350_/A2 _7092_/Y VDD VSS sg13cmos5l_a21oi_1
X_6113_ _6139_/B _6138_/A VDD VSS sg13cmos5l_inv_1
X_6044_ _6046_/C _6076_/B _6076_/A VDD VSS sg13cmos5l_xor2_1
XFILLER_86_626 VDD VSS sg13cmos5l_decap_8
XFILLER_85_136 VDD VSS sg13cmos5l_fill_1
XFILLER_67_895 VDD VSS sg13cmos5l_decap_8
XFILLER_54_534 VDD VSS sg13cmos5l_decap_4
XFILLER_66_394 VDD VSS sg13cmos5l_fill_1
XFILLER_82_832 VDD VSS sg13cmos5l_decap_8
X_6946_ _7065_/A _6843_/A _6974_/B _6945_/X VDD VSS sg13cmos5l_a21oi_1
XFILLER_50_740 VDD VSS sg13cmos5l_decap_8
XFILLER_50_751 VDD VSS sg13cmos5l_fill_1
X_6877_ _6877_/Y _6877_/A _6877_/B VDD VSS sg13cmos5l_nand2_2
X_5828_ _5829_/B _5773_/A _5828_/B VDD VSS sg13cmos5l_nand2b_1
X_5759_ _5768_/A _5817_/B _5817_/A VDD VSS sg13cmos5l_xor2_1
X_7429_ _7498_/B _7438_/A _7429_/B VDD VSS sg13cmos5l_xnor2_1
XFILLER_49_306 VDD VSS sg13cmos5l_decap_8
XFILLER_57_350 VDD VSS sg13cmos5l_fill_1
XFILLER_57_361 VDD VSS sg13cmos5l_decap_8
XFILLER_58_895 VDD VSS sg13cmos5l_decap_8
XFILLER_73_810 VDD VSS sg13cmos5l_decap_8
XFILLER_85_681 VDD VSS sg13cmos5l_decap_8
XFILLER_76_169 VDD VSS sg13cmos5l_fill_2
XFILLER_57_383 VDD VSS sg13cmos5l_decap_4
XFILLER_72_320 VDD VSS sg13cmos5l_decap_8
XFILLER_73_887 VDD VSS sg13cmos5l_decap_8
XFILLER_68_604 VDD VSS sg13cmos5l_decap_4
XFILLER_67_103 VDD VSS sg13cmos5l_decap_4
XFILLER_68_659 VDD VSS sg13cmos5l_fill_1
X_4090_ _4091_/A _4176_/A _4090_/B VDD VSS sg13cmos5l_xnor2_1
XFILLER_83_607 VDD VSS sg13cmos5l_decap_8
XFILLER_48_350 VDD VSS sg13cmos5l_fill_1
XFILLER_75_180 VDD VSS sg13cmos5l_fill_2
XFILLER_76_681 VDD VSS sg13cmos5l_decap_8
XFILLER_64_876 VDD VSS sg13cmos5l_decap_8
X_6800_ _6800_/Y _6800_/A _6800_/B VDD VSS sg13cmos5l_nor2_1
X_4992_ _4993_/B _4992_/A _5046_/A VDD VSS sg13cmos5l_xnor2_1
X_3943_ _3944_/B _4303_/B _5335_/A VDD VSS sg13cmos5l_nand2_1
X_6662_ _6676_/B _7702_/Q VDD VSS sg13cmos5l_inv_1
X_5613_ _5674_/B _5612_/B _5613_/B VDD VSS sg13cmos5l_nand2b_1
X_6593_ _6594_/B _6591_/B _7693_/Q VDD VSS sg13cmos5l_nand2b_1
X_5544_ _5544_/Y _5544_/A _5544_/B _5544_/C VDD VSS sg13cmos5l_nand3_1
X_5475_ _5542_/A _5536_/A _5475_/B VDD VSS sg13cmos5l_xnor2_1
X_7214_ _7217_/B _7720_/Q _7214_/B VDD VSS sg13cmos5l_xnor2_1
X_4426_ _4426_/X _4426_/A _4426_/B VDD VSS sg13cmos5l_and2_1
X_7145_ _7145_/Y _7141_/Y _7144_/Y _7302_/A1 VDD VSS sg13cmos5l_a21oi_1
XFILLER_87_913 VDD VSS sg13cmos5l_decap_4
X_4357_ _4358_/B _4357_/A VDD VSS sg13cmos5l_inv_1
Xbank_B_sram.gen_ihp_256x32.u_sram_256x32_1101 bank_B_sram.gen_ihp_256x32.u_sram_256x32_1101/L_LO
+ VDD VSS sg13cmos5l_tielo
Xbank_B_sram.gen_ihp_256x32.u_sram_256x32_1112 bank_B_sram.gen_ihp_256x32.u_sram_256x32_1112/L_LO
+ VDD VSS sg13cmos5l_tielo
X_7076_ _7076_/Y _7246_/B _7276_/S VDD VSS sg13cmos5l_nand2_1
X_4288_ _4289_/A _4288_/A _4297_/B VDD VSS sg13cmos5l_xor2_1
XFILLER_73_117 VDD VSS sg13cmos5l_decap_8
Xbank_B_sram.gen_ihp_256x32.u_sram_256x32_1123 bank_B_sram.gen_ihp_256x32.u_sram_256x32_1123/L_LO
+ VDD VSS sg13cmos5l_tielo
Xbank_B_sram.gen_ihp_256x32.u_sram_256x32_1134 bank_B_sram.gen_ihp_256x32.u_sram_256x32_1134/L_LO
+ VDD VSS sg13cmos5l_tielo
Xbank_B_sram.gen_ihp_256x32.u_sram_256x32_1145 bank_B_sram.gen_ihp_256x32.u_sram_256x32_1145/L_LO
+ VDD VSS sg13cmos5l_tielo
Xbank_B_sram.gen_ihp_256x32.u_sram_256x32_1156 bank_B_sram.gen_ihp_256x32.u_sram_256x32_1156/L_LO
+ VDD VSS sg13cmos5l_tielo
X_6027_ _6028_/B _6082_/A1 _6084_/A2 _6082_/B1 _6084_/B2 VDD VSS sg13cmos5l_a22oi_1
XFILLER_86_489 VDD VSS sg13cmos5l_decap_8
XFILLER_55_832 VDD VSS sg13cmos5l_decap_8
XFILLER_67_692 VDD VSS sg13cmos5l_fill_2
Xbank_B_sram.gen_ihp_256x32.u_sram_256x32_1167 bank_B_sram.gen_ihp_256x32.u_sram_256x32_1167/L_LO
+ VDD VSS sg13cmos5l_tielo
XFILLER_42_515 VDD VSS sg13cmos5l_decap_8
XFILLER_81_150 VDD VSS sg13cmos5l_fill_2
XFILLER_70_868 VDD VSS sg13cmos5l_decap_8
X_6929_ _6929_/Y _6929_/A _6929_/B VDD VSS sg13cmos5l_nand2_2
XFILLER_13_20 VDD VSS sg13cmos5l_fill_1
XFILLER_50_592 VDD VSS sg13cmos5l_decap_4
XFILLER_80_59 VDD VSS sg13cmos5l_decap_8
XFILLER_49_103 VDD VSS sg13cmos5l_fill_1
XFILLER_77_445 VDD VSS sg13cmos5l_decap_8
XFILLER_38_83 VDD VSS sg13cmos5l_fill_1
XFILLER_46_876 VDD VSS sg13cmos5l_decap_8
XFILLER_61_802 VDD VSS sg13cmos5l_fill_1
XFILLER_60_323 VDD VSS sg13cmos5l_decap_4
XFILLER_54_71 VDD VSS sg13cmos5l_decap_4
XFILLER_60_345 VDD VSS sg13cmos5l_decap_4
XFILLER_61_879 VDD VSS sg13cmos5l_decap_8
XFILLER_60_389 VDD VSS sg13cmos5l_fill_1
XFILLER_55_4 VDD VSS sg13cmos5l_fill_2
X_5260_ _5261_/B _5792_/B1 _5869_/A2 _5745_/B1 _5869_/B2 VDD VSS sg13cmos5l_a22oi_1
XFILLER_69_913 VDD VSS sg13cmos5l_decap_4
X_4211_ _4286_/B _4255_/A _4211_/B VDD VSS sg13cmos5l_xnor2_1
X_5191_ _5192_/B _5745_/B1 _5322_/A2 _5684_/B1 _5322_/B2 VDD VSS sg13cmos5l_a22oi_1
X_4142_ _4143_/A _4142_/A _4145_/A VDD VSS sg13cmos5l_xor2_1
XFILLER_84_905 VDD VSS sg13cmos5l_decap_8
XFILLER_68_467 VDD VSS sg13cmos5l_fill_1
X_4073_ _4073_/Y _5898_/B _4207_/A VDD VSS sg13cmos5l_nand2_1
XFILLER_84_916 VDD VSS sg13cmos5l_fill_2
XFILLER_48_180 VDD VSS sg13cmos5l_decap_8
XFILLER_37_876 VDD VSS sg13cmos5l_fill_2
XFILLER_52_824 VDD VSS sg13cmos5l_decap_8
XFILLER_63_172 VDD VSS sg13cmos5l_fill_2
X_4975_ _4976_/B _4975_/A _4975_/B VDD VSS sg13cmos5l_nand2_2
XFILLER_51_389 VDD VSS sg13cmos5l_decap_4
X_7694_ _7694_/Q clkload8/A _7694_/D place753/X VDD VSS sg13cmos5l_dfrbpq_1
Xclkload7 clkload7/Y clkload7/A VDD VSS sg13cmos5l_inv_1
X_6645_ _6647_/B _6688_/A _6645_/B VDD VSS sg13cmos5l_nand2_1
X_5527_ _5596_/B _5566_/B _5566_/A VDD VSS sg13cmos5l_xor2_1
XFILLER_59_27 VDD VSS sg13cmos5l_decap_8
X_5458_ _5461_/A _5517_/A _5459_/A _5519_/B VDD VSS sg13cmos5l_a21oi_1
XFILLER_115_11 VDD VSS sg13cmos5l_decap_8
XFILLER_59_412 VDD VSS sg13cmos5l_fill_2
X_5389_ _5389_/Y _5389_/A _5389_/B VDD VSS sg13cmos5l_nor2_1
X_4409_ _4476_/B _4471_/A _4470_/A VDD VSS sg13cmos5l_xnor2_1
XFILLER_87_710 VDD VSS sg13cmos5l_decap_8
X_7128_ _7129_/B _7108_/S _6922_/A _7127_/Y VDD VSS sg13cmos5l_o21ai_1
XFILLER_75_905 VDD VSS sg13cmos5l_decap_8
XFILLER_75_15 VDD VSS sg13cmos5l_fill_2
X_7059_ _7059_/Y _7059_/A VDD VSS sg13cmos5l_inv_1
XFILLER_87_787 VDD VSS sg13cmos5l_decap_8
XFILLER_75_916 VDD VSS sg13cmos5l_fill_2
XFILLER_46_117 VDD VSS sg13cmos5l_fill_2
XFILLER_46_128 VDD VSS sg13cmos5l_decap_8
XFILLER_55_651 VDD VSS sg13cmos5l_decap_8
XFILLER_54_172 VDD VSS sg13cmos5l_decap_4
XFILLER_70_610 VDD VSS sg13cmos5l_decap_8
XFILLER_43_857 VDD VSS sg13cmos5l_decap_8
XFILLER_70_654 VDD VSS sg13cmos5l_decap_4
XFILLER_40_51 VDD VSS sg13cmos5l_fill_2
XFILLER_27_8 VDD VSS sg13cmos5l_decap_8
XFILLER_78_743 VDD VSS sg13cmos5l_fill_1
XFILLER_77_220 VDD VSS sg13cmos5l_decap_8
XFILLER_78_765 VDD VSS sg13cmos5l_decap_8
XFILLER_77_242 VDD VSS sg13cmos5l_decap_8
XFILLER_37_117 VDD VSS sg13cmos5l_decap_4
XFILLER_46_640 VDD VSS sg13cmos5l_decap_8
XFILLER_73_470 VDD VSS sg13cmos5l_decap_4
XFILLER_60_120 VDD VSS sg13cmos5l_fill_2
XFILLER_61_632 VDD VSS sg13cmos5l_decap_8
XFILLER_60_153 VDD VSS sg13cmos5l_decap_4
X_4760_ _4807_/A _4708_/B _4708_/A _4759_/Y VDD VSS sg13cmos5l_a21oi_1
X_4691_ _4692_/B _4755_/B1 _4878_/A2 _4748_/A1 _4878_/B2 VDD VSS sg13cmos5l_a22oi_1
X_6430_ _6430_/Y _6431_/B _6431_/A VDD VSS sg13cmos5l_nor2_1
X_6361_ _6364_/B _6361_/A _7668_/Q _6372_/C VDD VSS sg13cmos5l_nand3_1
X_5312_ _5368_/B _5432_/A _5312_/B VDD VSS sg13cmos5l_xnor2_1
X_6292_ _6295_/B _6602_/A _6595_/B VDD VSS sg13cmos5l_nand2_2
XFILLER_69_710 VDD VSS sg13cmos5l_decap_8
XFILLER_69_721 VDD VSS sg13cmos5l_decap_8
X_5243_ _5252_/A _5181_/B _4967_/A _5243_/S VDD VSS sg13cmos5l_mux2_1
XFILLER_29_19 VDD VSS sg13cmos5l_fill_2
X_5174_ _5295_/A _5165_/B _5172_/Y _5173_/X VDD VSS sg13cmos5l_a21oi_1
XFILLER_57_916 VDD VSS sg13cmos5l_fill_2
XFILLER_84_702 VDD VSS sg13cmos5l_decap_8
XFILLER_45_29 VDD VSS sg13cmos5l_fill_1
X_4056_ _4057_/C _4056_/A VDD VSS sg13cmos5l_inv_1
XFILLER_84_779 VDD VSS sg13cmos5l_decap_8
XFILLER_37_684 VDD VSS sg13cmos5l_decap_8
XFILLER_37_695 VDD VSS sg13cmos5l_decap_4
XFILLER_83_289 VDD VSS sg13cmos5l_fill_2
XFILLER_40_816 VDD VSS sg13cmos5l_decap_8
XFILLER_51_197 VDD VSS sg13cmos5l_decap_8
XFILLER_61_17 VDD VSS sg13cmos5l_decap_8
XFILLER_61_28 VDD VSS sg13cmos5l_fill_1
X_4958_ _4958_/Y _4958_/A VDD VSS sg13cmos5l_inv_1
X_7677_ _7677_/Q clkload1/A _7677_/D place747/X VDD VSS sg13cmos5l_dfrbpq_1
X_4889_ _4890_/B _4947_/A _4947_/B _4889_/C VDD VSS sg13cmos5l_nor3_1
X_6628_ _6629_/B _6626_/B _7697_/Q VDD VSS sg13cmos5l_nand2b_1
X_6559_ _6567_/B _6559_/A VDD VSS sg13cmos5l_inv_1
Xinput802 _6205_/B bank_B_addr[6] VDD VSS sg13cmos5l_buf_1
Xinput813 input813/X bank_B_wdata[18] VDD VSS sg13cmos5l_buf_1
XFILLER_48_905 VDD VSS sg13cmos5l_decap_8
XFILLER_48_916 VDD VSS sg13cmos5l_fill_2
Xinput824 input824/X bank_B_wdata[28] VDD VSS sg13cmos5l_buf_1
Xinput835 input835/X bank_B_wdata[9] VDD VSS sg13cmos5l_buf_1
Xinput846 _7711_/D quant_cfg[20] VDD VSS sg13cmos5l_buf_1
XFILLER_87_573 VDD VSS sg13cmos5l_fill_2
XFILLER_74_201 VDD VSS sg13cmos5l_fill_1
Xinput857 _3995_/B quant_cfg[4] VDD VSS sg13cmos5l_buf_1
XFILLER_87_584 VDD VSS sg13cmos5l_decap_8
XFILLER_75_779 VDD VSS sg13cmos5l_decap_8
XFILLER_55_470 VDD VSS sg13cmos5l_fill_1
XFILLER_43_654 VDD VSS sg13cmos5l_decap_4
XFILLER_43_676 VDD VSS sg13cmos5l_fill_2
XFILLER_42_164 VDD VSS sg13cmos5l_decap_8
XFILLER_42_197 VDD VSS sg13cmos5l_decap_4
XFILLER_78_562 VDD VSS sg13cmos5l_decap_8
XFILLER_65_223 VDD VSS sg13cmos5l_fill_1
XFILLER_54_908 VDD VSS sg13cmos5l_decap_8
XFILLER_76_91 VDD VSS sg13cmos5l_decap_8
XFILLER_46_470 VDD VSS sg13cmos5l_decap_4
X_5930_ _5936_/C _5931_/B _5930_/B VDD VSS sg13cmos5l_nand2b_1
XFILLER_81_749 VDD VSS sg13cmos5l_decap_8
X_7600_ _7601_/B _7600_/A _7627_/B VDD VSS sg13cmos5l_nand2_2
X_5861_ _5862_/B _6085_/A _5861_/B VDD VSS sg13cmos5l_xnor2_1
XFILLER_61_495 VDD VSS sg13cmos5l_fill_1
X_5792_ _5857_/S _5859_/B1 _6082_/A2 _5792_/B1 _6082_/B2 VDD VSS sg13cmos5l_a22oi_1
X_4812_ _4813_/B _4873_/B1 _5322_/A2 _4878_/A1 _5322_/B2 VDD VSS sg13cmos5l_a22oi_1
X_7531_ _7533_/A _7531_/A _7531_/B VDD VSS sg13cmos5l_nand2_1
X_4743_ _4796_/A _4694_/B _4694_/A _4742_/X VDD VSS sg13cmos5l_a21oi_1
X_7462_ _7598_/A _7594_/A _7595_/A _7594_/B VDD VSS sg13cmos5l_nand3_1
X_6413_ _6823_/A _7673_/Q _6413_/B VDD VSS sg13cmos5l_xnor2_1
X_4674_ _4683_/A _4622_/B _4854_/A _4674_/S VDD VSS sg13cmos5l_mux2_1
X_7393_ _7501_/A _7567_/B _7567_/A VDD VSS sg13cmos5l_nor2b_2
X_6344_ _6638_/B _7709_/Q _6533_/B _6407_/A _6533_/C VDD VSS sg13cmos5l_nor4_1
X_6275_ _6323_/A _6275_/A _6275_/B VDD VSS sg13cmos5l_nand2_2
XFILLER_88_304 VDD VSS sg13cmos5l_decap_4
X_5226_ _5227_/B _5295_/A _5295_/B VDD VSS sg13cmos5l_xor2_1
X_5157_ _5157_/Y _5157_/A VDD VSS sg13cmos5l_inv_1
XFILLER_57_779 VDD VSS sg13cmos5l_fill_1
X_5088_ _5158_/B _5088_/A _5088_/B VDD VSS sg13cmos5l_xor2_1
X_4108_ _4143_/B _4108_/A _4108_/B _4108_/C VDD VSS sg13cmos5l_and3_1
XFILLER_56_289 VDD VSS sg13cmos5l_fill_1
X_4039_ _4102_/B _4067_/A _4067_/B VDD VSS sg13cmos5l_xor2_1
XFILLER_84_576 VDD VSS sg13cmos5l_decap_8
XFILLER_71_237 VDD VSS sg13cmos5l_fill_2
XFILLER_71_248 VDD VSS sg13cmos5l_decap_4
XFILLER_72_16 VDD VSS sg13cmos5l_decap_8
XFILLER_72_749 VDD VSS sg13cmos5l_fill_1
XFILLER_52_484 VDD VSS sg13cmos5l_fill_2
XFILLER_79_315 VDD VSS sg13cmos5l_decap_8
XFILLER_79_348 VDD VSS sg13cmos5l_decap_8
XFILLER_48_746 VDD VSS sg13cmos5l_fill_1
XFILLER_88_882 VDD VSS sg13cmos5l_decap_4
XFILLER_87_381 VDD VSS sg13cmos5l_decap_8
XFILLER_47_267 VDD VSS sg13cmos5l_decap_4
XFILLER_63_727 VDD VSS sg13cmos5l_decap_4
Xplace705 _7002_/B _7069_/B VDD VSS sg13cmos5l_buf_1
XFILLER_46_83 VDD VSS sg13cmos5l_decap_8
Xplace716 _6957_/S _6800_/A VDD VSS sg13cmos5l_buf_1
Xplace727 _4692_/A _4266_/A VDD VSS sg13cmos5l_buf_1
Xplace738 _5335_/A _4447_/A VDD VSS sg13cmos5l_buf_1
Xplace749 place749/X place750/X VDD VSS sg13cmos5l_buf_1
XFILLER_62_60 VDD VSS sg13cmos5l_fill_1
XFILLER_62_71 VDD VSS sg13cmos5l_decap_4
Xrebuffer2008 rebuffer2008/X rebuffer2009/X VDD VSS sg13cmos5l_buf_1
X_4390_ _4391_/B _4447_/A _4447_/B _4390_/C VDD VSS sg13cmos5l_nor3_1
Xrebuffer1307 rebuffer1307/X rebuffer1308/X VDD VSS sg13cmos5l_buf_1
Xrebuffer1329 _6879_/B _6506_/A VDD VSS sg13cmos5l_buf_1
Xrebuffer1318 rebuffer1318/X rebuffer1319/X VDD VSS sg13cmos5l_buf_1
X_6060_ _6061_/B _6085_/A _6060_/B VDD VSS sg13cmos5l_xnor2_1
XFILLER_86_808 VDD VSS sg13cmos5l_decap_8
XFILLER_79_882 VDD VSS sg13cmos5l_decap_8
XFILLER_78_392 VDD VSS sg13cmos5l_fill_2
XFILLER_54_738 VDD VSS sg13cmos5l_fill_2
XFILLER_53_215 VDD VSS sg13cmos5l_fill_2
XFILLER_53_226 VDD VSS sg13cmos5l_fill_1
X_6962_ _6962_/X _6962_/A _6968_/B VDD VSS sg13cmos5l_and2_1
XFILLER_81_546 VDD VSS sg13cmos5l_fill_2
XFILLER_81_535 VDD VSS sg13cmos5l_fill_1
XFILLER_50_911 VDD VSS sg13cmos5l_decap_8
X_6893_ _6894_/A _6332_/A _6834_/Y _6892_/Y _7350_/A2 VDD VSS sg13cmos5l_a22oi_1
X_5913_ _5913_/X _5913_/A _5913_/B VDD VSS sg13cmos5l_and2_1
XFILLER_81_579 VDD VSS sg13cmos5l_fill_1
X_5844_ _5847_/A _5848_/C _5889_/B VDD VSS sg13cmos5l_nand2_1
X_7514_ _7515_/B _7517_/B _7514_/B VDD VSS sg13cmos5l_nand2_1
X_5775_ _5775_/Y _5775_/A VDD VSS sg13cmos5l_inv_1
X_4726_ _4726_/X _4726_/A _4726_/B VDD VSS sg13cmos5l_and2_1
X_7445_ _7452_/A _7472_/A1 _7356_/Y _7472_/B1 VDD VSS sg13cmos5l_o21ai_1
X_4657_ _4660_/A _4713_/B _4657_/B VDD VSS sg13cmos5l_xnor2_1
X_7376_ _7377_/A _7376_/A _7376_/B VDD VSS sg13cmos5l_nor2_1
X_6327_ _6329_/A _6328_/A _6372_/C _7665_/Q VDD VSS sg13cmos5l_a21oi_1
X_4588_ _4589_/C _4588_/A VDD VSS sg13cmos5l_inv_1
X_6258_ _6267_/A _6258_/A _7706_/Q VDD VSS sg13cmos5l_nand2_1
XFILLER_69_381 VDD VSS sg13cmos5l_fill_2
Xrebuffer1896 _4231_/A1 _4185_/A VDD VSS sg13cmos5l_buf_1
Xrebuffer1885 _4269_/B _4224_/A VDD VSS sg13cmos5l_buf_1
Xrebuffer1874 _4139_/B _4097_/B VDD VSS sg13cmos5l_buf_1
X_6189_ _6189_/Y _6189_/A VDD VSS sg13cmos5l_inv_1
X_5209_ _5210_/B _5076_/A _5585_/A2 _5013_/A _5585_/B2 VDD VSS sg13cmos5l_a22oi_1
XFILLER_123_11 VDD VSS sg13cmos5l_decap_8
XFILLER_85_863 VDD VSS sg13cmos5l_decap_8
XFILLER_84_340 VDD VSS sg13cmos5l_fill_2
XFILLER_80_590 VDD VSS sg13cmos5l_decap_8
XFILLER_67_307 VDD VSS sg13cmos5l_fill_2
XFILLER_79_134 VDD VSS sg13cmos5l_fill_1
XFILLER_48_565 VDD VSS sg13cmos5l_decap_8
XFILLER_76_896 VDD VSS sg13cmos5l_decap_8
Xplace513 _6541_/A _6483_/A VDD VSS sg13cmos5l_buf_1
XFILLER_75_395 VDD VSS sg13cmos5l_decap_4
XFILLER_63_579 VDD VSS sg13cmos5l_fill_2
Xplace524 _6641_/C _6598_/C VDD VSS sg13cmos5l_buf_1
Xplace535 _7405_/A2 _7350_/A2 VDD VSS sg13cmos5l_buf_1
Xplace546 _5188_/B2 _4686_/B2 VDD VSS sg13cmos5l_buf_1
Xplace557 _4311_/B2 _4074_/Y VDD VSS sg13cmos5l_buf_1
Xplace568 _4531_/B2 _4175_/B2 VDD VSS sg13cmos5l_buf_1
Xplace579 _6927_/B _6407_/B VDD VSS sg13cmos5l_buf_1
X_5560_ _5563_/A _5621_/S _5560_/B VDD VSS sg13cmos5l_xnor2_1
X_5491_ _5601_/A _5437_/B _5437_/A _5490_/Y VDD VSS sg13cmos5l_a21oi_1
Xoutput903 bank_B_rdata[11] output903/A VDD VSS sg13cmos5l_buf_1
X_7230_ _7531_/A _7230_/A VDD VSS sg13cmos5l_inv_1
X_4442_ _4443_/B _4520_/B1 _3999_/A wire975/X _4642_/B2 VDD VSS sg13cmos5l_a22oi_1
Xoutput914 bank_B_rdata[21] wire972/X VDD VSS sg13cmos5l_buf_1
Xoutput925 bank_B_rdata[31] wire962/X VDD VSS sg13cmos5l_buf_1
X_7161_ _7163_/A _7161_/A _7191_/B VDD VSS sg13cmos5l_nand2_1
X_4373_ _4374_/B _4565_/B1 _4203_/A _3964_/C _4258_/Y VDD VSS sg13cmos5l_a22oi_1
X_7092_ _7092_/Y _7081_/Y _7084_/Y _7249_/B _6981_/A _7327_/A VDD VSS sg13cmos5l_a221oi_1
X_6112_ _6138_/A _5747_/A _6111_/A _6110_/Y _6111_/Y VDD VSS sg13cmos5l_a22oi_1
XFILLER_86_605 VDD VSS sg13cmos5l_decap_8
X_6043_ _6076_/A _5966_/A _6008_/A _6007_/Y VDD VSS sg13cmos5l_o21ai_1
XFILLER_85_115 VDD VSS sg13cmos5l_decap_4
XFILLER_85_159 VDD VSS sg13cmos5l_fill_1
XFILLER_54_513 VDD VSS sg13cmos5l_fill_2
XFILLER_67_874 VDD VSS sg13cmos5l_decap_8
XFILLER_82_811 VDD VSS sg13cmos5l_decap_8
XFILLER_39_598 VDD VSS sg13cmos5l_fill_2
XFILLER_54_524 VDD VSS sg13cmos5l_fill_2
XFILLER_81_310 VDD VSS sg13cmos5l_fill_1
X_6945_ _6945_/X _6945_/A _6945_/B VDD VSS sg13cmos5l_and2_1
XFILLER_82_888 VDD VSS sg13cmos5l_decap_8
X_6876_ _6877_/B _6875_/X _7072_/B VDD VSS sg13cmos5l_nand2b_1
X_5827_ _5829_/A _5774_/A _5827_/B VDD VSS sg13cmos5l_nand2b_1
X_5758_ _5817_/A _5758_/A _5813_/A VDD VSS sg13cmos5l_xnor2_1
X_4709_ _4710_/B _4746_/A _4709_/B VDD VSS sg13cmos5l_xnor2_1
X_5689_ _5692_/A _5744_/S _5689_/B VDD VSS sg13cmos5l_xnor2_1
X_7359_ _7513_/B _7359_/A _7360_/B VDD VSS sg13cmos5l_nand2_1
XFILLER_78_26 VDD VSS sg13cmos5l_fill_1
XFILLER_76_104 VDD VSS sg13cmos5l_decap_8
XFILLER_76_137 VDD VSS sg13cmos5l_fill_1
XFILLER_58_874 VDD VSS sg13cmos5l_decap_8
XFILLER_85_660 VDD VSS sg13cmos5l_decap_8
XFILLER_45_513 VDD VSS sg13cmos5l_fill_1
XFILLER_57_395 VDD VSS sg13cmos5l_fill_2
XFILLER_73_866 VDD VSS sg13cmos5l_decap_8
XFILLER_41_796 VDD VSS sg13cmos5l_decap_8
XFILLER_43_84 VDD VSS sg13cmos5l_fill_2
XFILLER_68_649 VDD VSS sg13cmos5l_decap_4
XFILLER_49_885 VDD VSS sg13cmos5l_decap_8
XFILLER_76_660 VDD VSS sg13cmos5l_decap_8
XFILLER_82_129 VDD VSS sg13cmos5l_decap_8
XFILLER_64_855 VDD VSS sg13cmos5l_decap_8
XFILLER_84_91 VDD VSS sg13cmos5l_fill_1
X_4991_ _5046_/A _4938_/B _4938_/A _4990_/X VDD VSS sg13cmos5l_a21oi_1
X_6661_ _6670_/A _6661_/A _6661_/B _6733_/B VDD VSS sg13cmos5l_nand3_1
X_6592_ _6594_/A _6765_/B _6765_/A VDD VSS sg13cmos5l_nand2_2
X_5612_ _5618_/C _5613_/B _5612_/B VDD VSS sg13cmos5l_nand2b_1
X_5543_ _5545_/A _5544_/A _5544_/C _5544_/B VDD VSS sg13cmos5l_a21oi_1
X_5474_ _5475_/B _5474_/A _5474_/B VDD VSS sg13cmos5l_xor2_1
X_7213_ _7214_/B _7302_/A1 _7209_/Y _7212_/Y VDD VSS sg13cmos5l_o21ai_1
X_4425_ _4486_/B _4489_/B _4489_/A VDD VSS sg13cmos5l_xor2_1
X_7144_ _7144_/Y _7144_/A _7144_/B _7144_/C VDD VSS sg13cmos5l_nand3_1
X_4356_ _4358_/A _4356_/A VDD VSS sg13cmos5l_inv_1
XFILLER_59_638 VDD VSS sg13cmos5l_fill_1
Xbank_B_sram.gen_ihp_256x32.u_sram_256x32_1102 bank_B_sram.gen_ihp_256x32.u_sram_256x32_1102/L_LO
+ VDD VSS sg13cmos5l_tielo
Xbank_B_sram.gen_ihp_256x32.u_sram_256x32_1113 bank_B_sram.gen_ihp_256x32.u_sram_256x32_1113/L_LO
+ VDD VSS sg13cmos5l_tielo
X_7075_ _7246_/B _7075_/A VDD VSS sg13cmos5l_inv_1
X_4287_ _4288_/A _4226_/A _4285_/Y _4286_/Y VDD VSS sg13cmos5l_o21ai_1
XFILLER_55_800 VDD VSS sg13cmos5l_fill_1
Xbank_B_sram.gen_ihp_256x32.u_sram_256x32_1124 bank_B_sram.gen_ihp_256x32.u_sram_256x32_1124/L_LO
+ VDD VSS sg13cmos5l_tielo
Xbank_B_sram.gen_ihp_256x32.u_sram_256x32_1135 bank_B_sram.gen_ihp_256x32.u_sram_256x32_1135/L_LO
+ VDD VSS sg13cmos5l_tielo
Xbank_B_sram.gen_ihp_256x32.u_sram_256x32_1146 bank_B_sram.gen_ihp_256x32.u_sram_256x32_1146/L_LO
+ VDD VSS sg13cmos5l_tielo
X_6026_ _6056_/S _6058_/B1 _6082_/A2 _6026_/B1 _6082_/B2 VDD VSS sg13cmos5l_a22oi_1
XFILLER_54_310 VDD VSS sg13cmos5l_decap_4
Xbank_B_sram.gen_ihp_256x32.u_sram_256x32_1157 bank_B_sram.gen_ihp_256x32.u_sram_256x32_1157/L_LO
+ VDD VSS sg13cmos5l_tielo
Xbank_B_sram.gen_ihp_256x32.u_sram_256x32_1168 bank_B_sram.gen_ihp_256x32.u_sram_256x32_1168/L_LO
+ VDD VSS sg13cmos5l_tielo
XFILLER_55_888 VDD VSS sg13cmos5l_decap_8
XFILLER_70_847 VDD VSS sg13cmos5l_decap_8
XFILLER_82_685 VDD VSS sg13cmos5l_decap_8
XFILLER_42_549 VDD VSS sg13cmos5l_fill_1
X_6928_ _6928_/Y _6927_/B _6770_/Y _6927_/Y VDD VSS sg13cmos5l_o21ai_1
X_6859_ _6859_/Y _6846_/Y _7134_/B _6858_/Y VDD VSS sg13cmos5l_a21oi_1
Xfanout88 _5788_/A _5780_/A VDD VSS sg13cmos5l_buf_1
Xfanout960 _4986_/B1 _4686_/A1 VDD VSS sg13cmos5l_buf_1
XFILLER_49_159 VDD VSS sg13cmos5l_decap_4
XFILLER_58_660 VDD VSS sg13cmos5l_fill_1
XFILLER_38_95 VDD VSS sg13cmos5l_decap_8
XFILLER_45_310 VDD VSS sg13cmos5l_decap_8
XFILLER_57_170 VDD VSS sg13cmos5l_decap_4
XFILLER_45_354 VDD VSS sg13cmos5l_decap_8
XFILLER_46_855 VDD VSS sg13cmos5l_decap_8
XFILLER_60_302 VDD VSS sg13cmos5l_decap_4
XFILLER_61_858 VDD VSS sg13cmos5l_decap_8
X_4210_ _4211_/B _4210_/A _4210_/B VDD VSS sg13cmos5l_xor2_1
Xclkbuf_0_clk_i clkbuf_0_clk_i/X clkbuf_0_clk_i/A VDD VSS sg13cmos5l_buf_16
X_4141_ _4142_/A _4146_/B _4146_/A VDD VSS sg13cmos5l_xor2_1
XFILLER_56_608 VDD VSS sg13cmos5l_decap_8
X_4072_ _4138_/B _4072_/A _4871_/A VDD VSS sg13cmos5l_nor2b_1
XFILLER_83_438 VDD VSS sg13cmos5l_fill_1
XFILLER_64_674 VDD VSS sg13cmos5l_fill_2
X_4974_ _4974_/X _4974_/A _4974_/B VDD VSS sg13cmos5l_and2_1
X_7693_ _7693_/Q clkload8/A _7693_/D place753/X VDD VSS sg13cmos5l_dfrbpq_1
X_6713_ _6990_/A _6713_/A _6713_/B _6901_/A VDD VSS sg13cmos5l_nand3_1
X_6644_ _6660_/B _7700_/Q VDD VSS sg13cmos5l_inv_1
Xclkload8 clkload8/Y clkload8/A VDD VSS sg13cmos5l_inv_1
X_6575_ _6583_/A _6575_/A _6575_/B VDD VSS sg13cmos5l_nand2_2
X_5526_ _5566_/A _5526_/A _5565_/A VDD VSS sg13cmos5l_xnor2_1
X_4408_ _4470_/A _4408_/A _4467_/A VDD VSS sg13cmos5l_xnor2_1
X_5388_ _5404_/A _5388_/A _5388_/B VDD VSS sg13cmos5l_xor2_1
X_7127_ _7127_/Y _7127_/A _7178_/S VDD VSS sg13cmos5l_nand2_1
X_4339_ _4340_/B _4404_/B _4404_/A VDD VSS sg13cmos5l_xor2_1
X_7058_ _7058_/Y _7050_/Y _7109_/A _7057_/Y VDD VSS sg13cmos5l_a21oi_2
XFILLER_87_766 VDD VSS sg13cmos5l_decap_8
X_6009_ _6013_/B _6168_/A _6009_/B VDD VSS sg13cmos5l_xnor2_1
XFILLER_42_302 VDD VSS sg13cmos5l_fill_2
XFILLER_43_836 VDD VSS sg13cmos5l_decap_8
XFILLER_55_685 VDD VSS sg13cmos5l_fill_2
XFILLER_42_335 VDD VSS sg13cmos5l_fill_1
XFILLER_24_20 VDD VSS sg13cmos5l_fill_1
XFILLER_40_74 VDD VSS sg13cmos5l_decap_4
XFILLER_78_711 VDD VSS sg13cmos5l_fill_1
XFILLER_38_619 VDD VSS sg13cmos5l_decap_4
XFILLER_49_83 VDD VSS sg13cmos5l_decap_8
XFILLER_66_917 VDD VSS sg13cmos5l_fill_1
XFILLER_65_416 VDD VSS sg13cmos5l_fill_1
XFILLER_77_298 VDD VSS sg13cmos5l_decap_8
XFILLER_45_151 VDD VSS sg13cmos5l_fill_2
XFILLER_65_71 VDD VSS sg13cmos5l_decap_8
XFILLER_60_198 VDD VSS sg13cmos5l_fill_2
X_4690_ _4742_/A _4690_/A _4690_/B VDD VSS sg13cmos5l_xnor2_1
X_6360_ _6362_/A _6361_/A _6372_/C _7668_/Q VDD VSS sg13cmos5l_a21oi_1
X_5311_ _5312_/B _5493_/B1 _5623_/A2 _5430_/B1 _5687_/B2 VDD VSS sg13cmos5l_a22oi_1
X_6291_ _6595_/B _6291_/A _6291_/B VDD VSS sg13cmos5l_nor2_1
X_5242_ _5290_/A _5242_/A _5304_/B VDD VSS sg13cmos5l_xnor2_1
X_5173_ _5173_/X _5173_/A _5173_/B VDD VSS sg13cmos5l_and2_1
X_4124_ _4134_/A _4322_/A _4124_/B VDD VSS sg13cmos5l_xnor2_1
XFILLER_37_652 VDD VSS sg13cmos5l_fill_1
X_4055_ _4058_/A _3955_/A _4056_/A _3960_/Y VDD VSS sg13cmos5l_a21oi_1
XFILLER_84_758 VDD VSS sg13cmos5l_decap_8
XFILLER_83_279 VDD VSS sg13cmos5l_fill_2
XFILLER_52_622 VDD VSS sg13cmos5l_fill_1
X_4957_ _5030_/B _5025_/A _4957_/B VDD VSS sg13cmos5l_xnor2_1
X_7676_ _7676_/Q clkload1/A _7676_/D place747/X VDD VSS sg13cmos5l_dfrbpq_1
X_4888_ _4889_/C _4888_/A VDD VSS sg13cmos5l_inv_1
XFILLER_124_8 VDD VSS sg13cmos5l_decap_8
X_6627_ _6629_/A _6753_/B _6753_/A VDD VSS sg13cmos5l_nand2_2
X_6558_ _6559_/A _6630_/A _6698_/B VDD VSS sg13cmos5l_nor2_1
X_6489_ _6504_/B _7682_/Q VDD VSS sg13cmos5l_inv_1
X_5509_ _5561_/B _5702_/A _5509_/B VDD VSS sg13cmos5l_xnor2_1
Xinput803 _6208_/B bank_B_addr[7] VDD VSS sg13cmos5l_buf_1
XFILLER_87_530 VDD VSS sg13cmos5l_decap_8
XFILLER_19_20 VDD VSS sg13cmos5l_fill_1
XFILLER_59_232 VDD VSS sg13cmos5l_decap_4
Xinput814 input814/X bank_B_wdata[19] VDD VSS sg13cmos5l_buf_1
Xinput825 input825/X bank_B_wdata[29] VDD VSS sg13cmos5l_buf_1
Xinput836 input836/X bank_B_we VDD VSS sg13cmos5l_buf_1
Xinput847 _7712_/D quant_cfg[21] VDD VSS sg13cmos5l_buf_1
Xinput858 _4044_/B quant_cfg[6] VDD VSS sg13cmos5l_buf_1
XFILLER_43_622 VDD VSS sg13cmos5l_fill_2
XFILLER_43_633 VDD VSS sg13cmos5l_decap_8
XFILLER_42_132 VDD VSS sg13cmos5l_decap_4
XFILLER_70_474 VDD VSS sg13cmos5l_fill_2
XFILLER_66_736 VDD VSS sg13cmos5l_decap_4
XFILLER_76_70 VDD VSS sg13cmos5l_decap_8
XFILLER_65_257 VDD VSS sg13cmos5l_decap_8
XFILLER_81_728 VDD VSS sg13cmos5l_decap_8
XFILLER_74_780 VDD VSS sg13cmos5l_decap_8
X_5860_ _5861_/B _5985_/B1 _6084_/A2 _5949_/B1 _6084_/B2 VDD VSS sg13cmos5l_a22oi_1
XFILLER_80_238 VDD VSS sg13cmos5l_decap_8
X_5791_ _5800_/A _5748_/B _5547_/A _5791_/S VDD VSS sg13cmos5l_mux2_1
X_7530_ _7613_/B _7530_/A _7530_/B VDD VSS sg13cmos5l_xnor2_1
X_4742_ _4742_/X _4742_/A _4742_/B VDD VSS sg13cmos5l_and2_1
X_7461_ _7594_/B _7461_/A _7585_/A VDD VSS sg13cmos5l_nand2_1
X_4673_ _4732_/A _4626_/B _4626_/A _4672_/Y VDD VSS sg13cmos5l_a21oi_1
X_6412_ _6413_/B _6409_/Y _6421_/A _6450_/A2 VDD VSS sg13cmos5l_o21ai_1
X_7392_ _7567_/A _7431_/B _7570_/A VDD VSS sg13cmos5l_xnor2_1
X_6274_ _6286_/A _6805_/A _6804_/A _6273_/Y VDD VSS sg13cmos5l_o21ai_1
X_5225_ _5295_/B _5302_/A _5225_/B VDD VSS sg13cmos5l_xnor2_1
XFILLER_69_563 VDD VSS sg13cmos5l_decap_4
XFILLER_69_574 VDD VSS sg13cmos5l_decap_4
X_5156_ _5160_/A _5217_/B _5156_/B VDD VSS sg13cmos5l_xnor2_1
XFILLER_56_235 VDD VSS sg13cmos5l_fill_2
X_5087_ _5088_/B _5127_/A _5087_/B VDD VSS sg13cmos5l_xnor2_1
X_4107_ _4144_/A _4107_/A _4106_/A VDD VSS sg13cmos5l_nor2b_2
XFILLER_84_555 VDD VSS sg13cmos5l_decap_8
X_4038_ _4067_/B _4012_/B _4643_/A _4037_/Y VDD VSS sg13cmos5l_a21oi_1
XFILLER_37_482 VDD VSS sg13cmos5l_fill_2
XFILLER_72_28 VDD VSS sg13cmos5l_decap_8
XFILLER_52_474 VDD VSS sg13cmos5l_fill_1
X_5989_ _5991_/A _5989_/A _5945_/A VDD VSS sg13cmos5l_nor2b_1
XFILLER_80_794 VDD VSS sg13cmos5l_decap_8
X_7728_ _7728_/Q _7728_/CLK _7728_/D place752/X VDD VSS sg13cmos5l_dfrbpq_1
X_7659_ _7659_/Q _7712_/CLK _7659_/D place750/X VDD VSS sg13cmos5l_dfrbpq_1
XFILLER_115_4 VDD VSS sg13cmos5l_decap_8
XFILLER_88_872 VDD VSS sg13cmos5l_decap_4
XFILLER_87_360 VDD VSS sg13cmos5l_decap_8
XFILLER_62_205 VDD VSS sg13cmos5l_decap_8
XFILLER_63_706 VDD VSS sg13cmos5l_fill_1
XFILLER_75_588 VDD VSS sg13cmos5l_decap_8
XFILLER_46_62 VDD VSS sg13cmos5l_decap_8
XFILLER_56_780 VDD VSS sg13cmos5l_fill_2
XFILLER_62_227 VDD VSS sg13cmos5l_decap_4
Xplace706 _7069_/B _7071_/B VDD VSS sg13cmos5l_buf_1
Xplace717 _6800_/A _6249_/A VDD VSS sg13cmos5l_buf_1
Xplace728 _5702_/A _5977_/B VDD VSS sg13cmos5l_buf_1
Xplace739 _4447_/A _4172_/A VDD VSS sg13cmos5l_buf_1
XFILLER_43_441 VDD VSS sg13cmos5l_decap_4
XFILLER_71_750 VDD VSS sg13cmos5l_fill_2
XFILLER_43_463 VDD VSS sg13cmos5l_decap_8
XFILLER_70_293 VDD VSS sg13cmos5l_fill_1
XFILLER_7_12 VDD VSS sg13cmos5l_decap_8
Xrebuffer2009 rebuffer2009/X _4184_/A VDD VSS sg13cmos5l_buf_1
Xrebuffer1308 rebuffer1308/X rebuffer1309/X VDD VSS sg13cmos5l_buf_1
Xrebuffer1319 rebuffer1319/X rebuffer1320/X VDD VSS sg13cmos5l_buf_1
X_5010_ _5020_/A _5141_/A _5010_/B VDD VSS sg13cmos5l_xnor2_1
XFILLER_79_861 VDD VSS sg13cmos5l_decap_8
XFILLER_78_382 VDD VSS sg13cmos5l_fill_2
XFILLER_53_205 VDD VSS sg13cmos5l_fill_2
XFILLER_66_577 VDD VSS sg13cmos5l_fill_2
XFILLER_66_588 VDD VSS sg13cmos5l_decap_4
XFILLER_66_599 VDD VSS sg13cmos5l_fill_2
X_6961_ _6961_/Y _6816_/A _6955_/B _6960_/X VDD VSS sg13cmos5l_a21oi_1
XFILLER_62_750 VDD VSS sg13cmos5l_fill_1
X_6892_ _6892_/Y _6891_/B _6859_/Y _6891_/Y VDD VSS sg13cmos5l_o21ai_1
X_5912_ _5915_/A _5948_/S _5912_/B VDD VSS sg13cmos5l_xnor2_1
XFILLER_62_772 VDD VSS sg13cmos5l_decap_8
X_5843_ _5889_/B _5842_/B _5843_/B VDD VSS sg13cmos5l_nand2b_1
X_7513_ _7515_/A _7513_/A _7513_/B VDD VSS sg13cmos5l_nand2_1
X_5774_ _5834_/A _5774_/A _5827_/B VDD VSS sg13cmos5l_xnor2_1
X_4725_ _4729_/A _4725_/A VDD VSS sg13cmos5l_inv_1
X_7444_ _7590_/A _7444_/A _7496_/A VDD VSS sg13cmos5l_nand2_2
X_4656_ _4657_/B _4656_/A _4714_/B VDD VSS sg13cmos5l_xor2_1
X_7375_ _7381_/A _7375_/A _7506_/B _7507_/B VDD VSS sg13cmos5l_nand3_1
X_4587_ _4590_/A _3964_/A _4588_/A _5204_/B1 VDD VSS sg13cmos5l_a21oi_1
XFILLER_88_102 VDD VSS sg13cmos5l_decap_8
X_6257_ _6805_/A _7659_/Q _6802_/A _6802_/B VDD VSS sg13cmos5l_nand3_1
XFILLER_77_809 VDD VSS sg13cmos5l_decap_8
XFILLER_69_360 VDD VSS sg13cmos5l_decap_8
Xrebuffer1897 _4230_/B _4184_/B VDD VSS sg13cmos5l_buf_1
Xrebuffer1886 _4080_/A1 _4063_/B VDD VSS sg13cmos5l_buf_1
Xrebuffer1875 _4298_/A1 _4289_/A VDD VSS sg13cmos5l_buf_1
X_6188_ _6188_/Y _6183_/Y _6209_/A1 _6187_/Y VDD VSS sg13cmos5l_a21oi_1
X_5208_ _5266_/A _5206_/B _5145_/A _5207_/Y VDD VSS sg13cmos5l_a21o_1
X_5139_ _5186_/A _5086_/B _5086_/A _5138_/Y VDD VSS sg13cmos5l_a21oi_1
XFILLER_85_842 VDD VSS sg13cmos5l_decap_8
XFILLER_57_577 VDD VSS sg13cmos5l_decap_8
XFILLER_84_352 VDD VSS sg13cmos5l_fill_1
XFILLER_84_396 VDD VSS sg13cmos5l_fill_2
XFILLER_37_290 VDD VSS sg13cmos5l_decap_4
XFILLER_41_901 VDD VSS sg13cmos5l_decap_8
XFILLER_52_293 VDD VSS sg13cmos5l_decap_8
XFILLER_79_102 VDD VSS sg13cmos5l_decap_8
XFILLER_87_190 VDD VSS sg13cmos5l_decap_8
XFILLER_57_83 VDD VSS sg13cmos5l_decap_4
XFILLER_76_875 VDD VSS sg13cmos5l_decap_8
XFILLER_75_341 VDD VSS sg13cmos5l_fill_2
XFILLER_44_750 VDD VSS sg13cmos5l_fill_1
Xplace514 _6621_/A _6602_/A VDD VSS sg13cmos5l_buf_1
Xplace525 _6598_/C _6552_/C VDD VSS sg13cmos5l_buf_1
Xplace536 _7350_/A2 _6418_/A VDD VSS sg13cmos5l_buf_1
Xplace547 _4686_/B2 _4258_/Y VDD VSS sg13cmos5l_buf_1
Xplace558 _5869_/A2 _4045_/Y VDD VSS sg13cmos5l_buf_1
Xplace569 _4175_/B2 _3979_/Y VDD VSS sg13cmos5l_buf_1
X_5490_ _5490_/Y _5490_/A _5436_/A VDD VSS sg13cmos5l_nor2b_1
X_4510_ _4517_/A _5060_/A _4510_/B VDD VSS sg13cmos5l_xnor2_1
X_4441_ _4506_/A _4396_/B _4396_/A _4440_/Y VDD VSS sg13cmos5l_a21oi_1
Xoutput904 bank_B_rdata[12] output904/A VDD VSS sg13cmos5l_buf_1
Xoutput915 bank_B_rdata[22] wire971/X VDD VSS sg13cmos5l_buf_1
Xoutput926 bank_B_rdata[3] _6219_/B VDD VSS sg13cmos5l_buf_1
X_6111_ _6111_/Y _6111_/A _6111_/B VDD VSS sg13cmos5l_nor2_1
X_4372_ _4403_/A _4416_/B _4416_/A VDD VSS sg13cmos5l_xor2_1
XFILLER_67_853 VDD VSS sg13cmos5l_decap_8
XFILLER_39_566 VDD VSS sg13cmos5l_fill_1
XFILLER_66_363 VDD VSS sg13cmos5l_fill_1
XFILLER_54_558 VDD VSS sg13cmos5l_decap_4
X_6944_ _6944_/Y _6940_/Y _7061_/B _6943_/Y VDD VSS sg13cmos5l_a21oi_1
XFILLER_82_867 VDD VSS sg13cmos5l_decap_8
XFILLER_81_388 VDD VSS sg13cmos5l_fill_2
X_6875_ _6875_/X _6872_/Y _6934_/S _6874_/Y VDD VSS sg13cmos5l_a21o_1
XFILLER_50_786 VDD VSS sg13cmos5l_fill_2
X_5826_ _5833_/B _5826_/A VDD VSS sg13cmos5l_inv_1
XFILLER_50_797 VDD VSS sg13cmos5l_fill_2
X_5757_ _5813_/A _5757_/A _5757_/B VDD VSS sg13cmos5l_xnor2_1
X_4708_ _4709_/B _4708_/A _4708_/B VDD VSS sg13cmos5l_xor2_1
X_7427_ _7429_/B _7326_/Y _7397_/A _7399_/A VDD VSS sg13cmos5l_a21o_1
X_5688_ _5689_/B _5747_/A _5688_/B VDD VSS sg13cmos5l_xnor2_1
X_4639_ _4684_/A _4595_/B _4595_/A _4638_/Y VDD VSS sg13cmos5l_a21oi_1
X_7358_ _7359_/A _7376_/A _7196_/Y _7357_/Y VDD VSS sg13cmos5l_o21ai_1
XFILLER_78_38 VDD VSS sg13cmos5l_fill_1
X_7289_ _7290_/C _7289_/A _7289_/B VDD VSS sg13cmos5l_nor2_1
X_6309_ _6310_/A _6309_/A _6786_/A VDD VSS sg13cmos5l_nand2_2
XFILLER_77_628 VDD VSS sg13cmos5l_fill_2
XFILLER_58_853 VDD VSS sg13cmos5l_decap_8
XFILLER_76_127 VDD VSS sg13cmos5l_decap_4
XFILLER_72_300 VDD VSS sg13cmos5l_fill_1
XFILLER_73_845 VDD VSS sg13cmos5l_decap_8
XFILLER_72_388 VDD VSS sg13cmos5l_fill_2
XFILLER_41_775 VDD VSS sg13cmos5l_decap_8
XFILLER_43_63 VDD VSS sg13cmos5l_decap_8
XFILLER_49_864 VDD VSS sg13cmos5l_decap_8
XFILLER_48_396 VDD VSS sg13cmos5l_fill_2
XFILLER_64_834 VDD VSS sg13cmos5l_decap_8
XFILLER_75_182 VDD VSS sg13cmos5l_fill_1
XFILLER_51_528 VDD VSS sg13cmos5l_fill_1
X_4990_ _4990_/X _4990_/A _4990_/B VDD VSS sg13cmos5l_and2_1
XFILLER_44_580 VDD VSS sg13cmos5l_decap_8
X_6660_ _6733_/B _6660_/A _6660_/B VDD VSS sg13cmos5l_nand2_1
X_6591_ _6765_/A _7693_/Q _6591_/B VDD VSS sg13cmos5l_xnor2_1
X_5611_ _5612_/B _5546_/A _5545_/A _5544_/Y VDD VSS sg13cmos5l_o21ai_1
X_5542_ _5544_/B _5542_/A _5542_/B VDD VSS sg13cmos5l_and2_1
X_5473_ _5474_/B _5473_/A _5473_/B VDD VSS sg13cmos5l_nand2_1
X_7212_ _7212_/Y _7141_/A _7211_/Y _7059_/A VDD VSS sg13cmos5l_o21ai_1
X_4424_ _4489_/A _6110_/B _4424_/B VDD VSS sg13cmos5l_xnor2_1
X_7143_ _7144_/C _6973_/Y _7187_/A VDD VSS sg13cmos5l_nand2b_1
X_4355_ _4471_/A _4355_/A VDD VSS sg13cmos5l_inv_1
XFILLER_59_606 VDD VSS sg13cmos5l_decap_4
X_7074_ _7075_/A _7070_/Y _7030_/B _7073_/Y VDD VSS sg13cmos5l_a21oi_1
Xbank_B_sram.gen_ihp_256x32.u_sram_256x32_1103 bank_B_sram.gen_ihp_256x32.u_sram_256x32_1103/L_LO
+ VDD VSS sg13cmos5l_tielo
X_4286_ _4286_/Y _4286_/A _4286_/B VDD VSS sg13cmos5l_nand2_1
XFILLER_86_425 VDD VSS sg13cmos5l_fill_2
Xbank_B_sram.gen_ihp_256x32.u_sram_256x32_1114 bank_B_sram.gen_ihp_256x32.u_sram_256x32_1114/L_LO
+ VDD VSS sg13cmos5l_tielo
Xbank_B_sram.gen_ihp_256x32.u_sram_256x32_1125 bank_B_sram.gen_ihp_256x32.u_sram_256x32_1125/L_LO
+ VDD VSS sg13cmos5l_tielo
Xbank_B_sram.gen_ihp_256x32.u_sram_256x32_1136 bank_B_sram.gen_ihp_256x32.u_sram_256x32_1136/L_LO
+ VDD VSS sg13cmos5l_tielo
Xbank_B_sram.gen_ihp_256x32.u_sram_256x32_1147 bank_B_sram.gen_ihp_256x32.u_sram_256x32_1147/L_LO
+ VDD VSS sg13cmos5l_tielo
X_6025_ _6049_/B _5983_/B _6025_/B VDD VSS sg13cmos5l_nand2b_1
Xbank_B_sram.gen_ihp_256x32.u_sram_256x32_1158 bank_B_sram.gen_ihp_256x32.u_sram_256x32_1158/L_LO
+ VDD VSS sg13cmos5l_tielo
Xbank_B_sram.gen_ihp_256x32.u_sram_256x32_1169 bank_B_sram.gen_ihp_256x32.u_sram_256x32_1169/L_LO
+ VDD VSS sg13cmos5l_tielo
XFILLER_55_867 VDD VSS sg13cmos5l_decap_8
XFILLER_82_664 VDD VSS sg13cmos5l_decap_8
XFILLER_70_826 VDD VSS sg13cmos5l_decap_8
X_6927_ _6927_/Y _6862_/X _6927_/B VDD VSS sg13cmos5l_nand2b_1
XFILLER_81_185 VDD VSS sg13cmos5l_decap_4
XFILLER_50_561 VDD VSS sg13cmos5l_decap_8
X_6858_ _6858_/Y _7112_/B _7112_/A VDD VSS sg13cmos5l_nor2_1
X_6789_ _6789_/Y _6974_/B _6974_/A _6788_/Y VDD VSS sg13cmos5l_o21ai_1
XFILLER_49_127 VDD VSS sg13cmos5l_decap_8
XFILLER_49_138 VDD VSS sg13cmos5l_fill_2
Xfanout950 _6026_/B1 _5801_/A1 VDD VSS sg13cmos5l_buf_1
Xfanout961 _5050_/B1 _4748_/A1 VDD VSS sg13cmos5l_buf_1
XFILLER_77_436 VDD VSS sg13cmos5l_decap_4
XFILLER_46_801 VDD VSS sg13cmos5l_fill_2
XFILLER_46_834 VDD VSS sg13cmos5l_decap_8
XFILLER_58_694 VDD VSS sg13cmos5l_fill_2
XFILLER_64_108 VDD VSS sg13cmos5l_decap_8
XFILLER_57_193 VDD VSS sg13cmos5l_decap_8
XFILLER_73_642 VDD VSS sg13cmos5l_fill_2
XFILLER_61_837 VDD VSS sg13cmos5l_decap_8
XFILLER_73_675 VDD VSS sg13cmos5l_decap_8
XFILLER_73_686 VDD VSS sg13cmos5l_fill_1
XFILLER_41_550 VDD VSS sg13cmos5l_fill_1
XFILLER_70_94 VDD VSS sg13cmos5l_fill_1
X_4140_ _4146_/A _4140_/A _4140_/B VDD VSS sg13cmos5l_nand2_2
XFILLER_79_92 VDD VSS sg13cmos5l_decap_8
XFILLER_68_425 VDD VSS sg13cmos5l_fill_2
XFILLER_37_801 VDD VSS sg13cmos5l_decap_8
X_4071_ _4690_/A _4207_/A VDD VSS sg13cmos5l_buf_1
XFILLER_48_160 VDD VSS sg13cmos5l_decap_8
XFILLER_64_631 VDD VSS sg13cmos5l_fill_2
XFILLER_64_664 VDD VSS sg13cmos5l_fill_1
XFILLER_51_314 VDD VSS sg13cmos5l_fill_2
XFILLER_51_336 VDD VSS sg13cmos5l_decap_4
XFILLER_52_859 VDD VSS sg13cmos5l_decap_8
XFILLER_63_185 VDD VSS sg13cmos5l_decap_4
XFILLER_63_196 VDD VSS sg13cmos5l_decap_4
X_4973_ _4977_/A _4973_/A VDD VSS sg13cmos5l_inv_1
XFILLER_51_369 VDD VSS sg13cmos5l_decap_8
X_7692_ _7692_/Q clkload7/A _7692_/D place751/X VDD VSS sg13cmos5l_dfrbpq_1
XFILLER_60_881 VDD VSS sg13cmos5l_decap_8
X_6643_ _6734_/A _6732_/B _6732_/A VDD VSS sg13cmos5l_nand2_2
Xclkload9 clkload9/Y clkload9/A VDD VSS sg13cmos5l_inv_1
X_6574_ _6575_/B _6570_/B _7691_/Q VDD VSS sg13cmos5l_nand2b_1
X_5525_ _5565_/A _5525_/A _5525_/B VDD VSS sg13cmos5l_xor2_1
X_5456_ _5466_/A _5757_/A _5456_/B VDD VSS sg13cmos5l_xnor2_1
X_4407_ _4467_/A _4407_/A _4407_/B VDD VSS sg13cmos5l_xor2_1
X_5387_ _5388_/B _5434_/A _5434_/B VDD VSS sg13cmos5l_xor2_1
XFILLER_59_414 VDD VSS sg13cmos5l_fill_1
X_7126_ _7126_/Y _7125_/Y _7126_/B VDD VSS sg13cmos5l_nand2b_1
X_4338_ _4404_/A _4283_/A _4336_/Y _4337_/Y VDD VSS sg13cmos5l_o21ai_1
XFILLER_87_745 VDD VSS sg13cmos5l_decap_8
XFILLER_86_222 VDD VSS sg13cmos5l_fill_2
X_7057_ _7057_/Y _7235_/B _7057_/B VDD VSS sg13cmos5l_nor2_1
X_4269_ _4269_/Y _4269_/A _4269_/B VDD VSS sg13cmos5l_nor2_1
XFILLER_46_119 VDD VSS sg13cmos5l_fill_1
X_6008_ _6009_/B _6008_/A _6007_/Y VDD VSS sg13cmos5l_nor2b_1
XFILLER_43_815 VDD VSS sg13cmos5l_decap_8
XFILLER_82_461 VDD VSS sg13cmos5l_decap_4
XFILLER_70_678 VDD VSS sg13cmos5l_decap_8
XFILLER_51_881 VDD VSS sg13cmos5l_decap_8
XFILLER_40_53 VDD VSS sg13cmos5l_fill_1
XFILLER_65_439 VDD VSS sg13cmos5l_decap_8
XFILLER_65_50 VDD VSS sg13cmos5l_fill_1
XFILLER_45_130 VDD VSS sg13cmos5l_fill_2
XFILLER_60_177 VDD VSS sg13cmos5l_fill_1
XFILLER_81_71 VDD VSS sg13cmos5l_fill_2
XFILLER_60_4 VDD VSS sg13cmos5l_fill_2
X_6290_ _6291_/B _6376_/A _7709_/Q _6533_/B VDD VSS sg13cmos5l_nand3_1
X_5310_ _5368_/A _5370_/B1 _5493_/A2 _5310_/B1 _5370_/B2 VDD VSS sg13cmos5l_a22oi_1
X_5241_ _5304_/B _5185_/B _5185_/A _5240_/Y VDD VSS sg13cmos5l_a21oi_1
XFILLER_68_211 VDD VSS sg13cmos5l_fill_2
X_5172_ _5172_/Y _5172_/A VDD VSS sg13cmos5l_inv_1
XFILLER_69_778 VDD VSS sg13cmos5l_fill_2
X_4123_ _4124_/B _4003_/A _4167_/A2 _4156_/A1 _4271_/B2 VDD VSS sg13cmos5l_a22oi_1
XFILLER_68_288 VDD VSS sg13cmos5l_fill_1
XFILLER_84_737 VDD VSS sg13cmos5l_decap_8
XFILLER_83_203 VDD VSS sg13cmos5l_decap_4
XFILLER_83_236 VDD VSS sg13cmos5l_fill_1
XFILLER_37_675 VDD VSS sg13cmos5l_fill_1
XFILLER_71_409 VDD VSS sg13cmos5l_fill_1
XFILLER_52_634 VDD VSS sg13cmos5l_decap_8
XFILLER_52_645 VDD VSS sg13cmos5l_decap_8
X_4956_ _4957_/B _4956_/A _5026_/B VDD VSS sg13cmos5l_xor2_1
X_7675_ _7675_/Q clkload3/A _7675_/D place747/X VDD VSS sg13cmos5l_dfrbpq_1
X_4887_ _4890_/A _5012_/A1 _4888_/A _5012_/B1 VDD VSS sg13cmos5l_a21oi_1
X_6626_ _6753_/A _7697_/Q _6626_/B VDD VSS sg13cmos5l_xnor2_1
X_6557_ _6630_/A _6557_/A VDD VSS sg13cmos5l_inv_1
XFILLER_10_12 VDD VSS sg13cmos5l_decap_8
X_5508_ _5509_/B _5575_/B1 _5871_/A2 _5508_/B1 _5871_/B2 VDD VSS sg13cmos5l_a22oi_1
X_6488_ _6497_/A _6488_/A _6835_/A VDD VSS sg13cmos5l_nand2_2
X_5439_ _5469_/A _5404_/B _5404_/A _5438_/Y VDD VSS sg13cmos5l_a21oi_1
Xinput804 input804/X bank_B_wdata[0] VDD VSS sg13cmos5l_buf_1
Xinput815 input815/X bank_B_wdata[1] VDD VSS sg13cmos5l_buf_1
Xinput826 input826/X bank_B_wdata[2] VDD VSS sg13cmos5l_buf_1
Xinput837 _4200_/B quant_cfg[10] VDD VSS sg13cmos5l_buf_1
X_7109_ _7109_/Y _7109_/A _7109_/B VDD VSS sg13cmos5l_nor2_1
XFILLER_47_406 VDD VSS sg13cmos5l_fill_2
XFILLER_47_417 VDD VSS sg13cmos5l_fill_1
Xinput848 _7713_/D quant_cfg[22] VDD VSS sg13cmos5l_buf_1
Xinput859 _4113_/A quant_cfg[7] VDD VSS sg13cmos5l_buf_1
XFILLER_87_575 VDD VSS sg13cmos5l_fill_1
XFILLER_47_439 VDD VSS sg13cmos5l_decap_8
XFILLER_55_461 VDD VSS sg13cmos5l_decap_8
XFILLER_35_20 VDD VSS sg13cmos5l_fill_1
XFILLER_82_280 VDD VSS sg13cmos5l_fill_1
XFILLER_43_678 VDD VSS sg13cmos5l_fill_1
XFILLER_32_8 VDD VSS sg13cmos5l_fill_2
XFILLER_38_428 VDD VSS sg13cmos5l_decap_4
XFILLER_65_214 VDD VSS sg13cmos5l_decap_8
XFILLER_66_759 VDD VSS sg13cmos5l_decap_8
XFILLER_46_461 VDD VSS sg13cmos5l_fill_1
XFILLER_81_707 VDD VSS sg13cmos5l_decap_8
XFILLER_61_442 VDD VSS sg13cmos5l_decap_8
X_4810_ _4817_/A _5060_/A _4810_/B VDD VSS sg13cmos5l_xnor2_1
XFILLER_61_475 VDD VSS sg13cmos5l_fill_2
X_5790_ _5825_/A _5752_/B _5752_/A _5789_/Y VDD VSS sg13cmos5l_a21oi_1
X_4741_ _4744_/A _4798_/S _4741_/B VDD VSS sg13cmos5l_xnor2_1
X_7460_ _7595_/A _7460_/A _7460_/B VDD VSS sg13cmos5l_xnor2_1
X_4672_ _4672_/Y _4672_/A _4625_/A VDD VSS sg13cmos5l_nor2b_1
X_6411_ _6421_/A _6420_/B VDD VSS sg13cmos5l_inv_1
X_7391_ _7570_/A _7376_/A _7263_/Y _7390_/Y VDD VSS sg13cmos5l_o21ai_1
XFILLER_51_0 VDD VSS sg13cmos5l_fill_2
X_6342_ _6346_/A _6336_/A _6342_/B VDD VSS sg13cmos5l_nand2b_2
X_6273_ _6273_/Y _6273_/A _7660_/Q _6802_/B VDD VSS sg13cmos5l_nand3_1
X_5224_ _5225_/B _5292_/B _5292_/A VDD VSS sg13cmos5l_xor2_1
XFILLER_88_328 VDD VSS sg13cmos5l_decap_4
XFILLER_69_542 VDD VSS sg13cmos5l_fill_1
XFILLER_57_737 VDD VSS sg13cmos5l_decap_8
XFILLER_69_586 VDD VSS sg13cmos5l_decap_4
X_5155_ _5156_/B _5155_/A _5218_/B VDD VSS sg13cmos5l_xor2_1
X_5086_ _5087_/B _5086_/A _5086_/B VDD VSS sg13cmos5l_xor2_1
X_4106_ _7666_/D _4106_/A _4107_/A VDD VSS sg13cmos5l_xnor2_1
XFILLER_56_258 VDD VSS sg13cmos5l_decap_4
XFILLER_72_729 VDD VSS sg13cmos5l_fill_1
X_4037_ _4037_/Y _4037_/A _4037_/B VDD VSS sg13cmos5l_nor2_1
XFILLER_71_239 VDD VSS sg13cmos5l_fill_1
XFILLER_52_442 VDD VSS sg13cmos5l_fill_2
X_5988_ _5992_/A _6024_/S _5988_/B VDD VSS sg13cmos5l_xnor2_1
XFILLER_80_773 VDD VSS sg13cmos5l_decap_8
X_7727_ _7727_/Q clkload6/A _7727_/D place752/X VDD VSS sg13cmos5l_dfrbpq_1
X_4939_ _4939_/Y _4939_/A _4939_/B VDD VSS sg13cmos5l_nor2_1
X_7658_ _7727_/D _7658_/A _7658_/B VDD VSS sg13cmos5l_nand2_2
X_6609_ _6610_/B _6607_/B _7695_/Q VDD VSS sg13cmos5l_nand2b_1
X_7589_ _7591_/A _7589_/A _7589_/B VDD VSS sg13cmos5l_nand2_1
XFILLER_79_306 VDD VSS sg13cmos5l_fill_1
XFILLER_88_862 VDD VSS sg13cmos5l_fill_2
XFILLER_48_737 VDD VSS sg13cmos5l_decap_8
XFILLER_88_895 VDD VSS sg13cmos5l_decap_8
Xplace707 _7071_/B _7061_/B VDD VSS sg13cmos5l_buf_1
Xplace718 _6227_/A _6223_/A VDD VSS sg13cmos5l_buf_1
Xplace729 _5977_/B _4266_/A VDD VSS sg13cmos5l_buf_1
XFILLER_70_261 VDD VSS sg13cmos5l_fill_2
Xrebuffer1309 rebuffer1309/X rebuffer1310/X VDD VSS sg13cmos5l_buf_1
XFILLER_79_840 VDD VSS sg13cmos5l_decap_8
XFILLER_78_372 VDD VSS sg13cmos5l_fill_2
XFILLER_38_214 VDD VSS sg13cmos5l_decap_8
XFILLER_38_236 VDD VSS sg13cmos5l_fill_2
XFILLER_54_718 VDD VSS sg13cmos5l_fill_1
X_6960_ _6960_/X _6960_/A _6968_/B VDD VSS sg13cmos5l_and2_1
XFILLER_47_781 VDD VSS sg13cmos5l_fill_1
XFILLER_53_217 VDD VSS sg13cmos5l_fill_1
X_5911_ _5912_/B _6085_/A _5911_/B VDD VSS sg13cmos5l_xnor2_1
X_6891_ _6891_/Y _7205_/B _6891_/B VDD VSS sg13cmos5l_nand2_1
X_5842_ _5848_/C _5843_/B _5842_/B VDD VSS sg13cmos5l_nand2b_1
XFILLER_61_272 VDD VSS sg13cmos5l_fill_1
XFILLER_61_283 VDD VSS sg13cmos5l_decap_8
X_5773_ _5827_/B _5773_/A _5828_/B VDD VSS sg13cmos5l_xnor2_1
X_7512_ _7621_/B _7512_/A VDD VSS sg13cmos5l_inv_1
X_4724_ _4725_/A _4724_/A _4724_/B VDD VSS sg13cmos5l_xor2_1
X_7443_ _7496_/A _7460_/A _7443_/B VDD VSS sg13cmos5l_xnor2_1
X_4655_ _4714_/B _4655_/A _4655_/B VDD VSS sg13cmos5l_xor2_1
X_7374_ _7507_/B _7374_/A _7570_/B VDD VSS sg13cmos5l_nand2_1
X_6325_ _6328_/A _6335_/A _6335_/B VDD VSS sg13cmos5l_xnor2_1
Xrebuffer1887 _5170_/B _5169_/Y VDD VSS sg13cmos5l_buf_1
Xrebuffer1876 _5039_/B _5105_/A VDD VSS sg13cmos5l_buf_1
X_6187_ _6187_/Y _6187_/A _6205_/A VDD VSS sg13cmos5l_nor2_1
X_5207_ _5207_/Y _5207_/A _5207_/B VDD VSS sg13cmos5l_nor2_1
XFILLER_85_821 VDD VSS sg13cmos5l_decap_8
Xrebuffer1898 _4191_/A _4188_/X VDD VSS sg13cmos5l_buf_1
X_5138_ _5138_/Y _5138_/A _5138_/B VDD VSS sg13cmos5l_nor2_1
XFILLER_57_556 VDD VSS sg13cmos5l_decap_8
XFILLER_84_342 VDD VSS sg13cmos5l_fill_1
XFILLER_72_515 VDD VSS sg13cmos5l_fill_1
X_5069_ _5088_/A _5069_/A _5069_/B VDD VSS sg13cmos5l_xor2_1
XFILLER_85_898 VDD VSS sg13cmos5l_decap_8
XFILLER_52_261 VDD VSS sg13cmos5l_decap_4
XFILLER_53_773 VDD VSS sg13cmos5l_decap_8
XFILLER_76_854 VDD VSS sg13cmos5l_decap_8
Xplace515 _6688_/A _6611_/A VDD VSS sg13cmos5l_buf_1
Xplace526 _6552_/C _6502_/C VDD VSS sg13cmos5l_buf_1
Xplace537 _7472_/A1 _7369_/A VDD VSS sg13cmos5l_buf_1
Xplace548 _6021_/B2 _5981_/B2 VDD VSS sg13cmos5l_buf_1
Xplace559 _5322_/A2 _4753_/A2 VDD VSS sg13cmos5l_buf_1
XFILLER_43_283 VDD VSS sg13cmos5l_fill_2
X_4440_ _4440_/Y _4440_/A _4440_/B VDD VSS sg13cmos5l_nor2_1
Xoutput905 bank_B_rdata[13] output905/A VDD VSS sg13cmos5l_buf_1
Xoutput916 bank_B_rdata[23] wire970/X VDD VSS sg13cmos5l_buf_1
Xoutput927 bank_B_rdata[4] _6221_/B VDD VSS sg13cmos5l_buf_1
X_6110_ _6110_/Y _6110_/A _6110_/B VDD VSS sg13cmos5l_nand2_1
X_4371_ _4416_/A _4417_/B _4417_/A VDD VSS sg13cmos5l_xor2_1
X_7090_ _7249_/B _7086_/Y _7168_/B _7089_/Y VDD VSS sg13cmos5l_a21oi_1
X_6041_ _6076_/B _6168_/A _6041_/B VDD VSS sg13cmos5l_xnor2_1
XFILLER_39_534 VDD VSS sg13cmos5l_decap_4
XFILLER_67_832 VDD VSS sg13cmos5l_decap_8
XFILLER_79_681 VDD VSS sg13cmos5l_decap_8
XFILLER_39_578 VDD VSS sg13cmos5l_fill_2
XFILLER_82_846 VDD VSS sg13cmos5l_decap_8
X_6943_ _6943_/Y _7082_/B _6943_/B VDD VSS sg13cmos5l_nor2_1
X_6874_ _6874_/Y _6934_/S _6874_/B VDD VSS sg13cmos5l_nor2_1
X_5825_ _5826_/A _5825_/A _5849_/B VDD VSS sg13cmos5l_xnor2_1
X_5756_ _5757_/B _5705_/A _3996_/Y _5459_/A _5756_/B2 VDD VSS sg13cmos5l_a22oi_1
X_5687_ _5688_/B _5859_/B1 _4301_/Y _5792_/B1 _5687_/B2 VDD VSS sg13cmos5l_a22oi_1
X_4707_ _4708_/B _4759_/A _4759_/B VDD VSS sg13cmos5l_xor2_1
X_7426_ _7582_/A _7438_/A _7426_/B VDD VSS sg13cmos5l_xnor2_1
X_4638_ _4638_/Y _4638_/A _4638_/B VDD VSS sg13cmos5l_nor2_1
X_7357_ _7357_/Y _7356_/Y _7405_/A2 _7377_/B VDD VSS sg13cmos5l_a21oi_1
X_4569_ _4616_/A _4517_/B _4517_/A _4568_/X VDD VSS sg13cmos5l_a21o_1
X_7288_ _7289_/B _7156_/B _7246_/A _7287_/Y VDD VSS sg13cmos5l_a21oi_1
X_6308_ _6786_/A _6308_/A _6310_/B VDD VSS sg13cmos5l_nor2b_2
Xhold2020 _6183_/A _7721_/Q VDD VSS sg13cmos5l_dlygate4sd3_1
XFILLER_77_607 VDD VSS sg13cmos5l_decap_8
XFILLER_58_832 VDD VSS sg13cmos5l_decap_8
XFILLER_57_342 VDD VSS sg13cmos5l_fill_1
XFILLER_73_824 VDD VSS sg13cmos5l_decap_8
XFILLER_85_695 VDD VSS sg13cmos5l_decap_8
XFILLER_57_397 VDD VSS sg13cmos5l_fill_1
XFILLER_72_334 VDD VSS sg13cmos5l_decap_8
XFILLER_60_518 VDD VSS sg13cmos5l_fill_1
XFILLER_41_754 VDD VSS sg13cmos5l_decap_8
XFILLER_43_86 VDD VSS sg13cmos5l_fill_1
XFILLER_49_843 VDD VSS sg13cmos5l_decap_8
XFILLER_67_128 VDD VSS sg13cmos5l_decap_4
XFILLER_48_342 VDD VSS sg13cmos5l_fill_2
XFILLER_76_640 VDD VSS sg13cmos5l_fill_1
XFILLER_48_364 VDD VSS sg13cmos5l_decap_8
XFILLER_63_301 VDD VSS sg13cmos5l_decap_8
XFILLER_76_695 VDD VSS sg13cmos5l_decap_4
X_6590_ _6591_/B _6603_/A _6588_/Y _6598_/C VDD VSS sg13cmos5l_o21ai_1
X_5610_ _5613_/B _5788_/A _5670_/A VDD VSS sg13cmos5l_xnor2_1
X_5541_ _5544_/C _5541_/A _5541_/B VDD VSS sg13cmos5l_nand2_1
X_7211_ _7211_/Y _7211_/A _7234_/B VDD VSS sg13cmos5l_nand2_1
X_5472_ _5473_/B _5405_/A _5472_/B VDD VSS sg13cmos5l_nand2b_1
X_4423_ _4424_/B wire990/X _4303_/A _4562_/B1 _4800_/B2 VDD VSS sg13cmos5l_a22oi_1
X_7142_ _7144_/A _7142_/A _7142_/B VDD VSS sg13cmos5l_nand2_1
X_4354_ _4410_/A _4411_/B _4354_/B VDD VSS sg13cmos5l_nand2_1
X_7073_ _7073_/Y _7071_/Y _7072_/Y _7030_/B VDD VSS sg13cmos5l_a21oi_1
XFILLER_58_128 VDD VSS sg13cmos5l_decap_8
Xbank_B_sram.gen_ihp_256x32.u_sram_256x32_1104 bank_B_sram.gen_ihp_256x32.u_sram_256x32_1104/L_LO
+ VDD VSS sg13cmos5l_tielo
X_6024_ _6031_/A _5988_/B _5788_/A _6024_/S VDD VSS sg13cmos5l_mux2_1
X_4285_ _4285_/Y _4285_/A VDD VSS sg13cmos5l_inv_1
Xbank_B_sram.gen_ihp_256x32.u_sram_256x32_1115 bank_B_sram.gen_ihp_256x32.u_sram_256x32_1115/L_LO
+ VDD VSS sg13cmos5l_tielo
Xbank_B_sram.gen_ihp_256x32.u_sram_256x32_1126 bank_B_sram.gen_ihp_256x32.u_sram_256x32_1126/L_LO
+ VDD VSS sg13cmos5l_tielo
Xbank_B_sram.gen_ihp_256x32.u_sram_256x32_1137 bank_B_sram.gen_ihp_256x32.u_sram_256x32_1137/L_LO
+ VDD VSS sg13cmos5l_tielo
XFILLER_86_459 VDD VSS sg13cmos5l_fill_2
XFILLER_66_161 VDD VSS sg13cmos5l_decap_8
Xbank_B_sram.gen_ihp_256x32.u_sram_256x32_1148 bank_B_sram.gen_ihp_256x32.u_sram_256x32_1148/L_LO
+ VDD VSS sg13cmos5l_tielo
Xbank_B_sram.gen_ihp_256x32.u_sram_256x32_1159 bank_B_sram.gen_ihp_256x32.u_sram_256x32_1159/L_LO
+ VDD VSS sg13cmos5l_tielo
XFILLER_39_397 VDD VSS sg13cmos5l_fill_2
XFILLER_55_846 VDD VSS sg13cmos5l_decap_8
XFILLER_66_194 VDD VSS sg13cmos5l_fill_1
XFILLER_82_643 VDD VSS sg13cmos5l_decap_8
XFILLER_42_529 VDD VSS sg13cmos5l_fill_2
XFILLER_54_356 VDD VSS sg13cmos5l_decap_8
X_6926_ _6988_/A _6926_/A _7059_/A VDD VSS sg13cmos5l_nand2_2
XFILLER_81_142 VDD VSS sg13cmos5l_fill_2
XFILLER_81_197 VDD VSS sg13cmos5l_fill_1
Xclkbuf_4_14_0_clk_i_regs clkload8/A clkbuf_0_clk_i_regs/X VDD VSS sg13cmos5l_buf_8
X_6857_ _7112_/A _7034_/A _7085_/B _6856_/X VDD VSS sg13cmos5l_a21oi_1
XFILLER_50_584 VDD VSS sg13cmos5l_decap_4
Xfanout57 _6168_/A _5884_/A VDD VSS sg13cmos5l_buf_1
X_6788_ _6788_/Y _6788_/A _6974_/B VDD VSS sg13cmos5l_nand2_1
X_5808_ _5816_/A _5808_/A _5808_/B VDD VSS sg13cmos5l_xor2_1
X_5739_ _5739_/Y _5739_/A _5692_/A VDD VSS sg13cmos5l_nor2b_1
X_7409_ _7414_/A _7431_/B _7409_/B VDD VSS sg13cmos5l_nor2_1
XFILLER_78_916 VDD VSS sg13cmos5l_fill_2
XFILLER_78_905 VDD VSS sg13cmos5l_decap_8
Xfanout940 _5493_/B1 _5066_/A1 VDD VSS sg13cmos5l_buf_1
Xfanout951 _6058_/B1 _5805_/B1 VDD VSS sg13cmos5l_buf_1
XFILLER_77_459 VDD VSS sg13cmos5l_decap_4
XFILLER_46_813 VDD VSS sg13cmos5l_decap_8
XFILLER_45_334 VDD VSS sg13cmos5l_decap_8
XFILLER_73_654 VDD VSS sg13cmos5l_decap_8
XFILLER_41_573 VDD VSS sg13cmos5l_fill_2
XFILLER_70_51 VDD VSS sg13cmos5l_decap_8
XFILLER_70_62 VDD VSS sg13cmos5l_decap_8
XFILLER_79_71 VDD VSS sg13cmos5l_fill_2
XFILLER_68_437 VDD VSS sg13cmos5l_fill_1
X_4070_ _4312_/A _4113_/A VDD VSS sg13cmos5l_buf_1
XFILLER_49_684 VDD VSS sg13cmos5l_decap_8
XFILLER_64_610 VDD VSS sg13cmos5l_decap_8
XFILLER_48_194 VDD VSS sg13cmos5l_decap_8
XFILLER_49_695 VDD VSS sg13cmos5l_fill_1
XFILLER_45_890 VDD VSS sg13cmos5l_decap_8
XFILLER_52_838 VDD VSS sg13cmos5l_decap_8
X_4972_ _4973_/A _4972_/A _4972_/B VDD VSS sg13cmos5l_xor2_1
XFILLER_60_860 VDD VSS sg13cmos5l_decap_8
X_7691_ _7691_/Q _7702_/CLK _7691_/D place754/X VDD VSS sg13cmos5l_dfrbpq_1
X_6642_ _6732_/A _6642_/A _6734_/B VDD VSS sg13cmos5l_nor2b_1
X_6573_ _6575_/A _6573_/A _6573_/B _6860_/A VDD VSS sg13cmos5l_nand3_1
X_5524_ _5525_/B _5579_/B _5579_/A VDD VSS sg13cmos5l_xor2_1
X_5455_ _5456_/B _5205_/A _5514_/A2 _5145_/A _5756_/B2 VDD VSS sg13cmos5l_a22oi_1
X_4406_ _4407_/B _4414_/B _4414_/A VDD VSS sg13cmos5l_xor2_1
X_7125_ _7125_/Y _6900_/B _6991_/B _7108_/S VDD VSS sg13cmos5l_a21oi_1
X_5386_ _5434_/B _5702_/A _5386_/B VDD VSS sg13cmos5l_xnor2_1
X_4337_ _4337_/Y _4337_/A _4337_/B VDD VSS sg13cmos5l_nand2_1
XFILLER_87_724 VDD VSS sg13cmos5l_decap_8
X_7056_ _7057_/B _7191_/A _7055_/X _7108_/S VDD VSS sg13cmos5l_mux2_1
X_4268_ _4337_/B _4268_/A _4268_/B VDD VSS sg13cmos5l_xor2_1
XFILLER_74_429 VDD VSS sg13cmos5l_decap_4
X_6007_ _6007_/Y _6007_/A _6007_/B _6007_/C VDD VSS sg13cmos5l_nand3_1
XFILLER_75_29 VDD VSS sg13cmos5l_decap_8
X_4199_ _6053_/B _4266_/A _4200_/B VDD VSS sg13cmos5l_nor2_1
XFILLER_54_131 VDD VSS sg13cmos5l_decap_8
XFILLER_55_665 VDD VSS sg13cmos5l_fill_2
XFILLER_42_304 VDD VSS sg13cmos5l_fill_1
XFILLER_42_326 VDD VSS sg13cmos5l_decap_8
XFILLER_54_186 VDD VSS sg13cmos5l_fill_2
XFILLER_70_624 VDD VSS sg13cmos5l_decap_8
XFILLER_42_348 VDD VSS sg13cmos5l_fill_1
XFILLER_51_860 VDD VSS sg13cmos5l_decap_8
X_6909_ _6925_/A _7225_/A _7109_/A _7225_/C VDD VSS sg13cmos5l_nand3_1
XFILLER_50_392 VDD VSS sg13cmos5l_fill_2
XFILLER_49_63 VDD VSS sg13cmos5l_decap_8
XFILLER_78_735 VDD VSS sg13cmos5l_fill_2
XFILLER_77_212 VDD VSS sg13cmos5l_fill_2
XFILLER_49_74 VDD VSS sg13cmos5l_fill_1
XFILLER_49_96 VDD VSS sg13cmos5l_decap_8
XFILLER_66_908 VDD VSS sg13cmos5l_decap_8
XFILLER_78_779 VDD VSS sg13cmos5l_decap_8
XFILLER_77_256 VDD VSS sg13cmos5l_decap_8
XFILLER_77_267 VDD VSS sg13cmos5l_fill_1
XFILLER_45_153 VDD VSS sg13cmos5l_fill_1
XFILLER_46_654 VDD VSS sg13cmos5l_decap_8
XFILLER_65_84 VDD VSS sg13cmos5l_decap_8
XFILLER_61_646 VDD VSS sg13cmos5l_fill_2
XFILLER_65_95 VDD VSS sg13cmos5l_decap_8
XFILLER_42_893 VDD VSS sg13cmos5l_decap_8
XFILLER_41_370 VDD VSS sg13cmos5l_fill_2
X_5240_ _5240_/Y _5240_/A _5184_/A VDD VSS sg13cmos5l_nor2b_1
XFILLER_69_735 VDD VSS sg13cmos5l_decap_8
X_5171_ _5227_/A _5546_/A _5171_/B VDD VSS sg13cmos5l_nor2_1
XFILLER_68_245 VDD VSS sg13cmos5l_decap_8
XFILLER_56_407 VDD VSS sg13cmos5l_decap_8
X_4053_ _4063_/A _4168_/A _4053_/B VDD VSS sg13cmos5l_xnor2_1
XFILLER_84_716 VDD VSS sg13cmos5l_decap_8
XFILLER_83_215 VDD VSS sg13cmos5l_fill_1
XFILLER_49_470 VDD VSS sg13cmos5l_fill_1
XFILLER_52_613 VDD VSS sg13cmos5l_fill_2
X_4955_ _5026_/B _4955_/A _4955_/B VDD VSS sg13cmos5l_xor2_1
X_7674_ _7674_/Q clkload1/A _7674_/D place746/X VDD VSS sg13cmos5l_dfrbpq_1
X_6625_ _6626_/B _6622_/Y _6632_/A _6641_/C VDD VSS sg13cmos5l_o21ai_1
X_6556_ _6557_/A _7141_/A _7274_/A VDD VSS sg13cmos5l_nor2_1
X_5507_ _5561_/A _5870_/A _5507_/B VDD VSS sg13cmos5l_xnor2_1
X_6487_ _6835_/A _7681_/Q _6487_/B VDD VSS sg13cmos5l_xnor2_1
X_5438_ _5438_/Y _5438_/A _5403_/B VDD VSS sg13cmos5l_nor2b_1
X_5369_ _5377_/A _5546_/A _5368_/A _5368_/Y VDD VSS sg13cmos5l_a21oi_1
XFILLER_19_11 VDD VSS sg13cmos5l_decap_8
XFILLER_59_245 VDD VSS sg13cmos5l_fill_2
Xinput805 input805/X bank_B_wdata[10] VDD VSS sg13cmos5l_buf_1
Xinput816 input816/X bank_B_wdata[20] VDD VSS sg13cmos5l_buf_1
Xinput827 input827/X bank_B_wdata[30] VDD VSS sg13cmos5l_buf_1
Xinput838 _4257_/B quant_cfg[11] VDD VSS sg13cmos5l_buf_1
X_7108_ _7109_/B _6762_/Y _6751_/A _7108_/S VDD VSS sg13cmos5l_mux2_1
XFILLER_87_554 VDD VSS sg13cmos5l_decap_8
XFILLER_59_278 VDD VSS sg13cmos5l_decap_8
XFILLER_59_289 VDD VSS sg13cmos5l_fill_1
Xinput849 _7714_/D quant_cfg[23] VDD VSS sg13cmos5l_buf_1
X_7039_ _7327_/B _7031_/Y _6891_/B _7038_/X VDD VSS sg13cmos5l_a21oi_1
XFILLER_87_598 VDD VSS sg13cmos5l_decap_8
XFILLER_71_900 VDD VSS sg13cmos5l_decap_8
XFILLER_43_624 VDD VSS sg13cmos5l_fill_1
XFILLER_83_782 VDD VSS sg13cmos5l_decap_8
XFILLER_42_178 VDD VSS sg13cmos5l_fill_1
XFILLER_51_20 VDD VSS sg13cmos5l_decap_8
XFILLER_51_53 VDD VSS sg13cmos5l_decap_8
XFILLER_65_204 VDD VSS sg13cmos5l_decap_4
XFILLER_66_716 VDD VSS sg13cmos5l_decap_8
XFILLER_76_50 VDD VSS sg13cmos5l_decap_8
XFILLER_65_237 VDD VSS sg13cmos5l_fill_1
XFILLER_73_292 VDD VSS sg13cmos5l_decap_4
X_4740_ _4741_/B _4988_/A _4740_/B VDD VSS sg13cmos5l_xnor2_1
X_4671_ _4724_/A _4671_/A _4671_/B VDD VSS sg13cmos5l_nor2_1
X_7390_ _7390_/Y _7268_/Y _7405_/A2 _7377_/B VDD VSS sg13cmos5l_a21oi_1
X_6410_ _6420_/B _6410_/A _6410_/B VDD VSS sg13cmos5l_nand2_2
X_6341_ _6350_/A _6341_/A _6341_/B VDD VSS sg13cmos5l_nand2_2
Xwire990 wire990/X wire990/A VDD VSS sg13cmos5l_buf_2
XFILLER_44_0 VDD VSS sg13cmos5l_fill_2
XFILLER_69_510 VDD VSS sg13cmos5l_decap_8
X_5223_ _5292_/A _5160_/B _5160_/A _5222_/Y VDD VSS sg13cmos5l_a21o_1
X_5154_ _5218_/B _5154_/A _5154_/B VDD VSS sg13cmos5l_xor2_1
X_4105_ _4107_/A _6182_/A _4103_/Y _4104_/Y VDD VSS sg13cmos5l_a21oi_1
X_5085_ _5086_/B _5138_/A _5138_/B VDD VSS sg13cmos5l_xor2_1
XFILLER_37_451 VDD VSS sg13cmos5l_fill_2
X_4036_ _4067_/A _4042_/B _4036_/B VDD VSS sg13cmos5l_xor2_1
XFILLER_65_793 VDD VSS sg13cmos5l_fill_1
XFILLER_80_752 VDD VSS sg13cmos5l_decap_8
X_5987_ _5988_/B _6085_/A _5987_/B VDD VSS sg13cmos5l_xnor2_1
X_7726_ _7726_/Q _7728_/CLK _7726_/D place752/X VDD VSS sg13cmos5l_dfrbpq_1
X_4938_ _4955_/A _4938_/A _4938_/B VDD VSS sg13cmos5l_xor2_1
XANTENNA_30 wire969/X VDD VSS sg13cmos5l_antennanp
X_7657_ _7658_/A _7657_/A _7657_/B VDD VSS sg13cmos5l_nand2_2
X_4869_ _4870_/B _5178_/B1 _5380_/A2 _5117_/B1 _5188_/B2 VDD VSS sg13cmos5l_a22oi_1
X_6608_ _6610_/A _6757_/B _6757_/A VDD VSS sg13cmos5l_nand2_2
X_7588_ _7592_/B _7588_/A _7625_/A VDD VSS sg13cmos5l_nand2_1
X_6539_ _6547_/A _6873_/B _6873_/A VDD VSS sg13cmos5l_nand2_2
XFILLER_79_329 VDD VSS sg13cmos5l_decap_4
XFILLER_48_705 VDD VSS sg13cmos5l_decap_8
XFILLER_87_351 VDD VSS sg13cmos5l_decap_4
XFILLER_87_395 VDD VSS sg13cmos5l_decap_8
XFILLER_75_524 VDD VSS sg13cmos5l_decap_8
XFILLER_75_579 VDD VSS sg13cmos5l_fill_1
XFILLER_75_568 VDD VSS sg13cmos5l_decap_8
XFILLER_44_911 VDD VSS sg13cmos5l_decap_8
XFILLER_56_793 VDD VSS sg13cmos5l_decap_8
Xplace708 _7061_/B _6976_/B VDD VSS sg13cmos5l_buf_1
Xplace719 _6209_/A1 _6223_/A VDD VSS sg13cmos5l_buf_1
XFILLER_46_97 VDD VSS sg13cmos5l_decap_8
XFILLER_43_476 VDD VSS sg13cmos5l_fill_1
XFILLER_70_273 VDD VSS sg13cmos5l_decap_8
XFILLER_87_71 VDD VSS sg13cmos5l_fill_2
XFILLER_79_896 VDD VSS sg13cmos5l_decap_8
X_5910_ _5911_/B _6026_/B1 _6084_/A2 _5985_/B1 _6084_/B2 VDD VSS sg13cmos5l_a22oi_1
XFILLER_62_730 VDD VSS sg13cmos5l_fill_1
X_6890_ _7205_/B _6890_/A VDD VSS sg13cmos5l_inv_2
XFILLER_61_240 VDD VSS sg13cmos5l_decap_8
X_5841_ _5842_/B _5927_/A _5780_/B _5840_/Y VDD VSS sg13cmos5l_o21ai_1
XFILLER_61_295 VDD VSS sg13cmos5l_fill_2
X_5772_ _5828_/B _5772_/A _5772_/B VDD VSS sg13cmos5l_xnor2_1
X_7511_ _7512_/A _7511_/A _7511_/B VDD VSS sg13cmos5l_xor2_1
X_4723_ _4724_/B _4785_/B _4785_/A VDD VSS sg13cmos5l_xor2_1
X_7442_ _7443_/B _7472_/A1 _7157_/Y _7472_/B1 VDD VSS sg13cmos5l_o21ai_1
X_4654_ _4655_/B _4684_/A _4654_/B VDD VSS sg13cmos5l_xnor2_1
X_7373_ _7506_/B _7373_/A _7570_/B VDD VSS sg13cmos5l_nand2_1
X_6324_ _6335_/B _6324_/A _6324_/B VDD VSS sg13cmos5l_nand2_2
X_6255_ _6255_/Y _6255_/A _6255_/B _6255_/C _6548_/B VDD VSS sg13cmos5l_nand4_1
X_5206_ _5207_/B _5460_/A _5206_/B _5206_/C VDD VSS sg13cmos5l_nor3_1
XFILLER_88_126 VDD VSS sg13cmos5l_decap_4
Xrebuffer1888 _4789_/B _4847_/A VDD VSS sg13cmos5l_buf_1
Xrebuffer1877 _4285_/A _4226_/B VDD VSS sg13cmos5l_buf_1
XFILLER_85_800 VDD VSS sg13cmos5l_decap_8
Xrebuffer1899 _4121_/A1 _4092_/B VDD VSS sg13cmos5l_buf_1
X_5137_ _5154_/A _5137_/A _5137_/B VDD VSS sg13cmos5l_xor2_1
XFILLER_84_310 VDD VSS sg13cmos5l_fill_2
XFILLER_45_719 VDD VSS sg13cmos5l_decap_8
XFILLER_57_546 VDD VSS sg13cmos5l_fill_1
X_5068_ _5069_/B _5123_/A _5123_/B VDD VSS sg13cmos5l_xor2_1
XFILLER_85_877 VDD VSS sg13cmos5l_decap_8
XFILLER_38_793 VDD VSS sg13cmos5l_decap_8
X_4019_ _4020_/B _4162_/A1 _4167_/A2 _3999_/B _4271_/B2 VDD VSS sg13cmos5l_a22oi_1
XFILLER_84_398 VDD VSS sg13cmos5l_fill_1
XFILLER_37_270 VDD VSS sg13cmos5l_fill_2
XFILLER_37_281 VDD VSS sg13cmos5l_fill_1
XFILLER_53_752 VDD VSS sg13cmos5l_decap_8
XFILLER_65_590 VDD VSS sg13cmos5l_fill_2
XFILLER_53_785 VDD VSS sg13cmos5l_decap_8
XFILLER_40_457 VDD VSS sg13cmos5l_decap_8
X_7709_ _7709_/Q clkload0/A _7709_/D place749/X VDD VSS sg13cmos5l_dfrbpq_2
XFILLER_57_30 VDD VSS sg13cmos5l_fill_2
XFILLER_87_181 VDD VSS sg13cmos5l_fill_1
XFILLER_76_833 VDD VSS sg13cmos5l_decap_8
XFILLER_75_332 VDD VSS sg13cmos5l_fill_1
XFILLER_63_516 VDD VSS sg13cmos5l_fill_2
XFILLER_63_527 VDD VSS sg13cmos5l_fill_1
Xplace516 _6611_/A _6323_/A VDD VSS sg13cmos5l_buf_1
Xplace527 _6502_/C _6381_/B1 VDD VSS sg13cmos5l_buf_1
Xplace538 _7376_/A _7369_/A VDD VSS sg13cmos5l_buf_1
XFILLER_44_785 VDD VSS sg13cmos5l_decap_8
XFILLER_73_62 VDD VSS sg13cmos5l_decap_8
Xplace549 _5981_/B2 _4258_/Y VDD VSS sg13cmos5l_buf_1
Xoutput906 bank_B_rdata[14] output906/A VDD VSS sg13cmos5l_buf_1
Xoutput917 bank_B_rdata[24] wire969/X VDD VSS sg13cmos5l_buf_1
Xoutput928 bank_B_rdata[5] _6223_/B VDD VSS sg13cmos5l_buf_1
X_4370_ _4417_/A _4318_/B _4318_/A _4369_/X VDD VSS sg13cmos5l_a21o_1
X_6040_ _6041_/B _6073_/B _6073_/A VDD VSS sg13cmos5l_xnor2_1
XFILLER_86_619 VDD VSS sg13cmos5l_decap_8
XFILLER_79_660 VDD VSS sg13cmos5l_decap_8
XFILLER_85_129 VDD VSS sg13cmos5l_fill_2
XFILLER_67_888 VDD VSS sg13cmos5l_decap_8
XFILLER_82_825 VDD VSS sg13cmos5l_decap_8
XFILLER_54_538 VDD VSS sg13cmos5l_fill_2
X_6942_ _6943_/B _6941_/B _6841_/X _6941_/Y VDD VSS sg13cmos5l_o21ai_1
XFILLER_81_335 VDD VSS sg13cmos5l_fill_1
X_6873_ _6874_/B _6873_/A _6873_/B VDD VSS sg13cmos5l_xnor2_1
XFILLER_50_733 VDD VSS sg13cmos5l_decap_8
X_5824_ _5849_/B _5850_/B _5824_/B VDD VSS sg13cmos5l_xnor2_1
XFILLER_50_777 VDD VSS sg13cmos5l_decap_4
X_4706_ _4759_/B _5018_/A _4706_/B VDD VSS sg13cmos5l_xnor2_1
X_7425_ _7426_/B _7472_/A1 _7058_/Y _7472_/B1 VDD VSS sg13cmos5l_o21ai_1
X_4637_ _4655_/A _4637_/A _4637_/B VDD VSS sg13cmos5l_xor2_1
X_7356_ _7356_/Y _7356_/A VDD VSS sg13cmos5l_inv_1
X_4568_ _4568_/X _4568_/A _4568_/B VDD VSS sg13cmos5l_and2_1
X_7287_ _7287_/Y _7163_/A _7163_/C _7246_/A VDD VSS sg13cmos5l_a21oi_1
X_6307_ _6310_/B _6307_/A _7663_/Q _6328_/C VDD VSS sg13cmos5l_nand3_1
X_4499_ _4503_/B _4560_/A _4560_/B VDD VSS sg13cmos5l_xnor2_1
Xhold2021 _6195_/A _7724_/Q VDD VSS sg13cmos5l_dlygate4sd3_1
X_6238_ _6241_/A _6238_/A _6255_/C _6548_/B VDD VSS sg13cmos5l_nand3_1
X_6169_ _6172_/A _6178_/A _6169_/B VDD VSS sg13cmos5l_xnor2_1
XFILLER_69_181 VDD VSS sg13cmos5l_fill_1
XFILLER_73_803 VDD VSS sg13cmos5l_decap_8
XFILLER_45_505 VDD VSS sg13cmos5l_fill_2
XFILLER_58_888 VDD VSS sg13cmos5l_decap_8
XFILLER_72_313 VDD VSS sg13cmos5l_decap_8
XFILLER_85_674 VDD VSS sg13cmos5l_decap_8
XFILLER_84_151 VDD VSS sg13cmos5l_decap_8
XFILLER_41_711 VDD VSS sg13cmos5l_decap_8
XFILLER_43_32 VDD VSS sg13cmos5l_decap_8
XFILLER_53_593 VDD VSS sg13cmos5l_fill_1
XFILLER_40_221 VDD VSS sg13cmos5l_fill_1
XFILLER_80_390 VDD VSS sg13cmos5l_fill_1
XFILLER_40_287 VDD VSS sg13cmos5l_fill_2
XFILLER_4_15 VDD VSS sg13cmos5l_decap_4
XFILLER_49_822 VDD VSS sg13cmos5l_decap_8
XFILLER_67_107 VDD VSS sg13cmos5l_fill_2
XFILLER_68_73 VDD VSS sg13cmos5l_fill_1
XFILLER_49_899 VDD VSS sg13cmos5l_decap_8
XFILLER_76_674 VDD VSS sg13cmos5l_decap_8
XFILLER_63_335 VDD VSS sg13cmos5l_fill_1
XFILLER_64_869 VDD VSS sg13cmos5l_decap_8
XFILLER_75_173 VDD VSS sg13cmos5l_decap_8
XFILLER_75_195 VDD VSS sg13cmos5l_decap_4
XFILLER_84_83 VDD VSS sg13cmos5l_fill_1
XFILLER_84_72 VDD VSS sg13cmos5l_decap_8
X_5540_ _5544_/A _5608_/B VDD VSS sg13cmos5l_inv_1
X_5471_ _5473_/A _5406_/B _5471_/B VDD VSS sg13cmos5l_nand2b_1
X_7210_ _7211_/A _7210_/A _7233_/B _7210_/C VDD VSS sg13cmos5l_nand3_1
X_4422_ _4489_/B _4422_/A _4495_/A VDD VSS sg13cmos5l_nor2_1
X_7141_ _7141_/Y _7141_/A _7141_/B VDD VSS sg13cmos5l_nor2_1
X_4353_ _7671_/D _4353_/A _4353_/B VDD VSS sg13cmos5l_xor2_1
X_7072_ _7072_/Y _7072_/A _7072_/B VDD VSS sg13cmos5l_nand2_1
X_4284_ _4297_/B _4337_/B _4337_/A VDD VSS sg13cmos5l_xor2_1
XFILLER_87_917 VDD VSS sg13cmos5l_fill_1
XFILLER_87_906 VDD VSS sg13cmos5l_decap_8
X_6023_ _6032_/A _6025_/B _6057_/B VDD VSS sg13cmos5l_xnor2_1
Xbank_B_sram.gen_ihp_256x32.u_sram_256x32_1105 bank_B_sram.gen_ihp_256x32.u_sram_256x32_1105/L_LO
+ VDD VSS sg13cmos5l_tielo
Xbank_B_sram.gen_ihp_256x32.u_sram_256x32_1116 bank_B_sram.gen_ihp_256x32.u_sram_256x32_1116/L_LO
+ VDD VSS sg13cmos5l_tielo
Xbank_B_sram.gen_ihp_256x32.u_sram_256x32_1127 bank_B_sram.gen_ihp_256x32.u_sram_256x32_1127/L_LO
+ VDD VSS sg13cmos5l_tielo
Xbank_B_sram.gen_ihp_256x32.u_sram_256x32_1138 bank_B_sram.gen_ihp_256x32.u_sram_256x32_1138/L_LO
+ VDD VSS sg13cmos5l_tielo
XFILLER_86_449 VDD VSS sg13cmos5l_fill_2
XFILLER_55_825 VDD VSS sg13cmos5l_decap_8
Xbank_B_sram.gen_ihp_256x32.u_sram_256x32_1149 bank_B_sram.gen_ihp_256x32.u_sram_256x32_1149/L_LO
+ VDD VSS sg13cmos5l_tielo
XFILLER_54_346 VDD VSS sg13cmos5l_decap_4
XFILLER_82_622 VDD VSS sg13cmos5l_decap_8
XFILLER_54_368 VDD VSS sg13cmos5l_fill_2
X_6925_ _6926_/A _6925_/A _7111_/A _7318_/B VDD VSS sg13cmos5l_nand3_1
XFILLER_81_132 VDD VSS sg13cmos5l_fill_2
XFILLER_120_15 VDD VSS sg13cmos5l_decap_4
XFILLER_82_699 VDD VSS sg13cmos5l_decap_8
X_6856_ _6856_/X _7012_/A _7078_/B VDD VSS sg13cmos5l_and2_1
X_6787_ _6788_/A _6787_/A _6787_/B VDD VSS sg13cmos5l_xnor2_1
X_5807_ _5808_/B _5863_/A _5863_/B VDD VSS sg13cmos5l_xor2_1
X_3999_ _4000_/B _3999_/A _3999_/B VDD VSS sg13cmos5l_nand2_1
X_5738_ _5840_/B _5738_/A _5727_/A VDD VSS sg13cmos5l_nor2b_1
X_5669_ _5733_/B _5927_/A _5676_/A VDD VSS sg13cmos5l_xnor2_1
X_7408_ _7415_/A _7501_/A _7408_/B _7500_/A VDD VSS sg13cmos5l_nand3_1
X_7339_ _7347_/A _7369_/A _7104_/Y _7338_/Y VDD VSS sg13cmos5l_o21ai_1
XFILLER_77_405 VDD VSS sg13cmos5l_fill_1
Xfanout941 _5557_/B1 _5193_/B1 VDD VSS sg13cmos5l_buf_1
Xfanout952 _6082_/B1 _5871_/B1 VDD VSS sg13cmos5l_buf_1
XFILLER_38_65 VDD VSS sg13cmos5l_decap_4
XFILLER_46_803 VDD VSS sg13cmos5l_fill_1
XFILLER_57_151 VDD VSS sg13cmos5l_decap_4
XFILLER_46_869 VDD VSS sg13cmos5l_decap_8
XFILLER_58_696 VDD VSS sg13cmos5l_fill_1
XFILLER_73_644 VDD VSS sg13cmos5l_fill_1
XFILLER_85_482 VDD VSS sg13cmos5l_decap_4
XFILLER_54_31 VDD VSS sg13cmos5l_decap_8
XFILLER_54_75 VDD VSS sg13cmos5l_fill_1
XFILLER_54_880 VDD VSS sg13cmos5l_decap_8
XFILLER_60_316 VDD VSS sg13cmos5l_decap_8
XFILLER_60_327 VDD VSS sg13cmos5l_fill_2
XFILLER_72_176 VDD VSS sg13cmos5l_fill_2
XFILLER_41_541 VDD VSS sg13cmos5l_decap_8
XFILLER_41_563 VDD VSS sg13cmos5l_decap_4
XFILLER_69_906 VDD VSS sg13cmos5l_decap_8
XFILLER_69_917 VDD VSS sg13cmos5l_fill_1
XFILLER_37_825 VDD VSS sg13cmos5l_fill_2
XFILLER_83_419 VDD VSS sg13cmos5l_fill_1
XFILLER_63_143 VDD VSS sg13cmos5l_fill_2
XFILLER_63_165 VDD VSS sg13cmos5l_decap_8
X_4971_ _4972_/B _5035_/B _5035_/A VDD VSS sg13cmos5l_xor2_1
X_7690_ _7690_/Q clkload9/A _7690_/D place754/X VDD VSS sg13cmos5l_dfrbpq_1
X_6641_ _6734_/B _6641_/A _7699_/Q _6641_/C VDD VSS sg13cmos5l_nand3_1
X_5523_ _5579_/A _5645_/A _5523_/B VDD VSS sg13cmos5l_xnor2_1
X_5454_ _5501_/A _5402_/B _5402_/A _5453_/Y VDD VSS sg13cmos5l_a21oi_1
X_5385_ _5386_/B _5385_/A1 _5385_/A2 _5558_/A1 _5385_/B2 VDD VSS sg13cmos5l_a22oi_1
X_4405_ _4414_/A _4340_/B _4340_/A _4404_/X VDD VSS sg13cmos5l_a21o_1
X_7124_ _7176_/B _7124_/A VDD VSS sg13cmos5l_inv_1
X_4336_ _4336_/Y _4336_/A VDD VSS sg13cmos5l_inv_1
XFILLER_87_703 VDD VSS sg13cmos5l_decap_8
XFILLER_86_213 VDD VSS sg13cmos5l_fill_2
X_7055_ _7055_/X _6906_/B _7046_/B _7054_/X VDD VSS sg13cmos5l_a21o_1
X_4267_ _4268_/B _4305_/A _4305_/B VDD VSS sg13cmos5l_xor2_1
XFILLER_86_224 VDD VSS sg13cmos5l_fill_1
XFILLER_67_460 VDD VSS sg13cmos5l_fill_2
X_6006_ _6008_/A _6007_/A _6007_/C _6007_/B VDD VSS sg13cmos5l_a21oi_1
X_4198_ _6022_/A _4374_/A VDD VSS sg13cmos5l_inv_1
XFILLER_54_121 VDD VSS sg13cmos5l_fill_2
XFILLER_82_430 VDD VSS sg13cmos5l_fill_1
XFILLER_82_441 VDD VSS sg13cmos5l_fill_1
XFILLER_54_176 VDD VSS sg13cmos5l_fill_2
XFILLER_70_647 VDD VSS sg13cmos5l_decap_8
XFILLER_70_658 VDD VSS sg13cmos5l_fill_2
X_6908_ _7225_/C _7127_/A _7162_/B VDD VSS sg13cmos5l_nand2_1
X_6839_ _6839_/Y _6939_/B _6941_/B VDD VSS sg13cmos5l_nand2_1
XFILLER_40_44 VDD VSS sg13cmos5l_fill_2
XFILLER_78_725 VDD VSS sg13cmos5l_decap_4
XFILLER_78_758 VDD VSS sg13cmos5l_decap_8
Xrebuffer1290 _6798_/A _6299_/B VDD VSS sg13cmos5l_buf_1
XFILLER_46_633 VDD VSS sg13cmos5l_decap_8
XFILLER_86_780 VDD VSS sg13cmos5l_decap_8
XFILLER_45_132 VDD VSS sg13cmos5l_fill_1
XFILLER_60_102 VDD VSS sg13cmos5l_decap_8
XFILLER_61_625 VDD VSS sg13cmos5l_decap_8
XFILLER_73_474 VDD VSS sg13cmos5l_fill_1
XFILLER_60_146 VDD VSS sg13cmos5l_decap_8
XFILLER_42_872 VDD VSS sg13cmos5l_decap_8
XFILLER_81_51 VDD VSS sg13cmos5l_fill_2
X_5170_ _7684_/D _5170_/A _5170_/B VDD VSS sg13cmos5l_xor2_1
XFILLER_57_909 VDD VSS sg13cmos5l_decap_8
XFILLER_68_235 VDD VSS sg13cmos5l_fill_2
X_4121_ _4135_/B _4121_/A1 _4092_/A _4120_/Y VDD VSS sg13cmos5l_a21oi_2
X_4052_ _4053_/B wire989/X _4167_/A2 _4162_/A1 _4271_/B2 VDD VSS sg13cmos5l_a22oi_1
XFILLER_37_699 VDD VSS sg13cmos5l_fill_1
XFILLER_64_496 VDD VSS sg13cmos5l_fill_1
XFILLER_40_809 VDD VSS sg13cmos5l_decap_8
X_4954_ _4955_/B _4994_/A _4954_/B VDD VSS sg13cmos5l_xnor2_1
X_7673_ _7673_/Q clkload3/A _7673_/D place746/X VDD VSS sg13cmos5l_dfrbpq_1
X_4885_ _4895_/A _5141_/A _4885_/B VDD VSS sg13cmos5l_xnor2_1
X_6624_ _6632_/A _6631_/B _6631_/C VDD VSS sg13cmos5l_nor2_1
X_6555_ _6564_/A _6555_/A _6555_/B _6869_/B VDD VSS sg13cmos5l_nand3_1
X_5506_ _5507_/B _5985_/B1 _5869_/A2 _5949_/B1 _5869_/B2 VDD VSS sg13cmos5l_a22oi_1
X_6486_ _6487_/B _6491_/A _6485_/Y _6461_/C VDD VSS sg13cmos5l_o21ai_1
X_5437_ _5530_/B _5437_/A _5437_/B VDD VSS sg13cmos5l_xor2_1
X_5368_ _5368_/Y _5368_/A _5368_/B VDD VSS sg13cmos5l_nor2_1
Xinput806 input806/X bank_B_wdata[11] VDD VSS sg13cmos5l_buf_1
Xinput817 input817/X bank_B_wdata[21] VDD VSS sg13cmos5l_buf_1
Xinput828 input828/X bank_B_wdata[31] VDD VSS sg13cmos5l_buf_1
X_7107_ _7107_/Y _7178_/S _7106_/Y _7126_/B VDD VSS sg13cmos5l_o21ai_1
X_5299_ _5360_/A _5299_/A _5233_/B VDD VSS sg13cmos5l_nor2b_2
X_4319_ _4319_/Y _4319_/A _4319_/B VDD VSS sg13cmos5l_nor2_1
XFILLER_47_408 VDD VSS sg13cmos5l_fill_1
Xinput839 _4300_/B quant_cfg[12] VDD VSS sg13cmos5l_buf_1
X_7038_ _7038_/X _7038_/A _7144_/B VDD VSS sg13cmos5l_and2_1
XFILLER_87_566 VDD VSS sg13cmos5l_decap_8
XFILLER_67_290 VDD VSS sg13cmos5l_fill_1
XFILLER_83_761 VDD VSS sg13cmos5l_decap_8
XFILLER_43_647 VDD VSS sg13cmos5l_decap_8
XFILLER_55_496 VDD VSS sg13cmos5l_decap_8
XFILLER_42_146 VDD VSS sg13cmos5l_decap_4
XFILLER_70_466 VDD VSS sg13cmos5l_decap_4
XFILLER_50_190 VDD VSS sg13cmos5l_fill_2
XFILLER_78_555 VDD VSS sg13cmos5l_decap_8
XFILLER_18_8 VDD VSS sg13cmos5l_decap_8
XFILLER_76_84 VDD VSS sg13cmos5l_decap_8
XFILLER_46_430 VDD VSS sg13cmos5l_fill_2
XFILLER_62_901 VDD VSS sg13cmos5l_decap_8
XFILLER_74_794 VDD VSS sg13cmos5l_decap_8
XFILLER_61_422 VDD VSS sg13cmos5l_fill_1
XFILLER_42_691 VDD VSS sg13cmos5l_decap_4
X_4670_ _7676_/D _4727_/B _4670_/B VDD VSS sg13cmos5l_xor2_1
Xwire980 wire980/X wire980/A VDD VSS sg13cmos5l_buf_8
X_6340_ _6341_/A _6340_/A _6790_/A VDD VSS sg13cmos5l_nand2_2
Xwire991 _5395_/A wire991/A VDD VSS sg13cmos5l_buf_2
X_6271_ _6804_/A _6273_/A _6802_/B _7660_/Q VDD VSS sg13cmos5l_a21oi_1
X_5222_ _5222_/Y _5222_/A _5161_/B VDD VSS sg13cmos5l_nor2b_1
XFILLER_88_308 VDD VSS sg13cmos5l_fill_1
X_5153_ _5154_/B _5186_/A _5153_/B VDD VSS sg13cmos5l_xnor2_1
X_4104_ _4104_/Y _6181_/A _6181_/B VDD VSS sg13cmos5l_nor2_1
XFILLER_69_599 VDD VSS sg13cmos5l_decap_8
X_5084_ _5138_/B _5586_/A _5084_/B VDD VSS sg13cmos5l_xnor2_1
XFILLER_84_514 VDD VSS sg13cmos5l_decap_8
X_4035_ _4036_/B _4033_/Y _4009_/B _4034_/Y VDD VSS sg13cmos5l_a21oi_1
XFILLER_84_569 VDD VSS sg13cmos5l_decap_8
XFILLER_52_444 VDD VSS sg13cmos5l_fill_1
XFILLER_64_282 VDD VSS sg13cmos5l_decap_8
XFILLER_80_742 VDD VSS sg13cmos5l_decap_4
X_5986_ _5987_/B _6082_/B1 _6084_/A2 _6058_/B1 _6084_/B2 VDD VSS sg13cmos5l_a22oi_1
XFILLER_40_639 VDD VSS sg13cmos5l_fill_2
X_7725_ _7725_/Q clkload6/A _7725_/D place752/X VDD VSS sg13cmos5l_dfrbpq_1
X_4937_ _4938_/B _4990_/A _4990_/B VDD VSS sg13cmos5l_xor2_1
XANTENNA_20 _6200_/Y VDD VSS sg13cmos5l_antennanp
XANTENNA_31 wire970/X VDD VSS sg13cmos5l_antennanp
X_7656_ _7657_/B _7656_/A _7537_/A VDD VSS sg13cmos5l_nor2b_1
X_4868_ _4898_/A _4834_/B _4834_/A _4867_/Y VDD VSS sg13cmos5l_a21oi_1
XFILLER_122_8 VDD VSS sg13cmos5l_decap_8
X_6607_ _6757_/A _7695_/Q _6607_/B VDD VSS sg13cmos5l_xnor2_1
X_7587_ _7625_/A _7587_/A _7587_/B VDD VSS sg13cmos5l_xnor2_1
X_4799_ _4858_/S _4859_/B1 _5050_/A2 _4799_/B1 _4920_/B2 VDD VSS sg13cmos5l_a22oi_1
X_6538_ _6873_/A _6538_/A _6870_/B VDD VSS sg13cmos5l_nor2b_1
X_6469_ _6470_/B _6476_/A _6468_/X _6461_/C VDD VSS sg13cmos5l_o21ai_1
XFILLER_87_330 VDD VSS sg13cmos5l_fill_2
XFILLER_88_886 VDD VSS sg13cmos5l_fill_1
XFILLER_87_341 VDD VSS sg13cmos5l_fill_2
XFILLER_87_374 VDD VSS sg13cmos5l_fill_1
XFILLER_46_32 VDD VSS sg13cmos5l_fill_2
XFILLER_75_547 VDD VSS sg13cmos5l_fill_2
XFILLER_56_761 VDD VSS sg13cmos5l_fill_1
Xplace709 _6941_/B _6800_/A VDD VSS sg13cmos5l_buf_1
XFILLER_70_252 VDD VSS sg13cmos5l_decap_4
XFILLER_70_263 VDD VSS sg13cmos5l_fill_1
XFILLER_71_786 VDD VSS sg13cmos5l_fill_2
XFILLER_79_875 VDD VSS sg13cmos5l_decap_8
XFILLER_38_227 VDD VSS sg13cmos5l_decap_4
XFILLER_74_580 VDD VSS sg13cmos5l_decap_8
XFILLER_74_591 VDD VSS sg13cmos5l_fill_2
XFILLER_50_904 VDD VSS sg13cmos5l_decap_8
X_5840_ _5840_/Y _5840_/A _5840_/B VDD VSS sg13cmos5l_nand2_1
XFILLER_61_263 VDD VSS sg13cmos5l_fill_1
X_5771_ _5772_/B _5822_/A _5822_/B VDD VSS sg13cmos5l_xnor2_1
X_7510_ _7511_/B _7510_/A _7510_/B VDD VSS sg13cmos5l_nand2_1
X_4722_ _4785_/A _4665_/B _4665_/A _4721_/X VDD VSS sg13cmos5l_a21o_1
X_7441_ _7444_/A _7441_/A _7441_/B VDD VSS sg13cmos5l_nand2_2
X_4653_ _4654_/B _4653_/A _4653_/B VDD VSS sg13cmos5l_xor2_1
X_4584_ _4595_/A _4643_/A _4584_/B VDD VSS sg13cmos5l_xnor2_1
X_6323_ _6335_/A _6323_/A _6621_/B VDD VSS sg13cmos5l_nor2_1
XFILLER_107_16 VDD VSS sg13cmos5l_fill_2
X_5205_ _5206_/C _5205_/A VDD VSS sg13cmos5l_inv_1
XFILLER_88_149 VDD VSS sg13cmos5l_decap_8
Xrebuffer1878 _4296_/A _4290_/B VDD VSS sg13cmos5l_buf_1
Xrebuffer1867 _4233_/C _4237_/B VDD VSS sg13cmos5l_buf_1
XFILLER_69_374 VDD VSS sg13cmos5l_decap_8
Xrebuffer1889 _4413_/B _4475_/A VDD VSS sg13cmos5l_buf_1
X_5136_ _5137_/B _5182_/A _5182_/B VDD VSS sg13cmos5l_xor2_1
X_5067_ _5123_/B _5194_/A _5067_/B VDD VSS sg13cmos5l_xnor2_1
XFILLER_85_856 VDD VSS sg13cmos5l_decap_8
XFILLER_38_772 VDD VSS sg13cmos5l_decap_8
XFILLER_84_366 VDD VSS sg13cmos5l_decap_4
XFILLER_72_539 VDD VSS sg13cmos5l_decap_8
XFILLER_41_915 VDD VSS sg13cmos5l_fill_2
X_5969_ _5971_/C _6015_/B _6015_/A VDD VSS sg13cmos5l_xor2_1
X_7708_ _7708_/Q clkload5/A _7708_/D place749/X VDD VSS sg13cmos5l_dfrbpq_2
X_7639_ _7640_/A _7657_/A _7639_/B VDD VSS sg13cmos5l_nand2_2
XFILLER_113_4 VDD VSS sg13cmos5l_decap_8
XFILLER_79_116 VDD VSS sg13cmos5l_decap_4
XFILLER_88_661 VDD VSS sg13cmos5l_fill_2
XFILLER_48_503 VDD VSS sg13cmos5l_fill_2
XFILLER_57_53 VDD VSS sg13cmos5l_fill_2
XFILLER_76_812 VDD VSS sg13cmos5l_decap_8
XFILLER_76_889 VDD VSS sg13cmos5l_decap_8
XFILLER_75_366 VDD VSS sg13cmos5l_fill_2
Xplace517 _7289_/A _6490_/A VDD VSS sg13cmos5l_buf_1
Xplace528 _6372_/C _6328_/C VDD VSS sg13cmos5l_buf_1
XFILLER_43_252 VDD VSS sg13cmos5l_decap_8
XFILLER_71_550 VDD VSS sg13cmos5l_decap_8
Xplace539 _7369_/A _7327_/A VDD VSS sg13cmos5l_buf_1
XFILLER_43_285 VDD VSS sg13cmos5l_fill_1
XFILLER_71_572 VDD VSS sg13cmos5l_fill_2
XFILLER_71_583 VDD VSS sg13cmos5l_fill_2
Xoutput907 bank_B_rdata[15] output907/A VDD VSS sg13cmos5l_buf_1
Xoutput918 bank_B_rdata[25] wire968/X VDD VSS sg13cmos5l_buf_1
Xoutput929 bank_B_rdata[6] _6225_/B VDD VSS sg13cmos5l_buf_1
XFILLER_39_514 VDD VSS sg13cmos5l_fill_2
XFILLER_66_300 VDD VSS sg13cmos5l_fill_1
XFILLER_85_119 VDD VSS sg13cmos5l_fill_2
XFILLER_67_867 VDD VSS sg13cmos5l_decap_8
XFILLER_82_804 VDD VSS sg13cmos5l_decap_8
XFILLER_54_506 VDD VSS sg13cmos5l_fill_2
XFILLER_81_303 VDD VSS sg13cmos5l_fill_2
X_6941_ _6941_/Y _6941_/A _6941_/B VDD VSS sg13cmos5l_nand2_1
X_6872_ _6872_/Y _6872_/A VDD VSS sg13cmos5l_inv_1
XFILLER_81_358 VDD VSS sg13cmos5l_decap_8
X_5823_ _5824_/B _5821_/Y _5772_/A _5822_/Y VDD VSS sg13cmos5l_a21oi_1
X_5754_ _5817_/B _5754_/A _5754_/B VDD VSS sg13cmos5l_nand2_1
X_4705_ _4706_/B _4588_/A _3951_/A _4820_/B1 _5017_/B2 VDD VSS sg13cmos5l_a22oi_1
XFILLER_118_15 VDD VSS sg13cmos5l_decap_4
X_4636_ _4637_/B _4680_/A _4680_/B VDD VSS sg13cmos5l_xor2_1
X_7355_ _7361_/A _7355_/A _7355_/B _7518_/A VDD VSS sg13cmos5l_nand3_1
X_6306_ _6308_/A _6307_/A _6328_/C _7663_/Q VDD VSS sg13cmos5l_a21oi_1
X_4567_ _4616_/B _4618_/S _4567_/B VDD VSS sg13cmos5l_xnor2_1
X_7286_ _7290_/B _7166_/A _7235_/B _7285_/Y VDD VSS sg13cmos5l_a21oi_1
X_4498_ _4560_/B _5045_/A _4498_/B VDD VSS sg13cmos5l_xnor2_1
X_6237_ _6548_/B _7710_/Q VDD VSS sg13cmos5l_inv_4
Xhold2022 _6204_/A _7727_/Q VDD VSS sg13cmos5l_dlygate4sd3_1
X_6168_ _6169_/B _6168_/A _6168_/B VDD VSS sg13cmos5l_xnor2_1
XFILLER_58_867 VDD VSS sg13cmos5l_decap_8
XFILLER_85_653 VDD VSS sg13cmos5l_decap_8
X_6099_ _6132_/B _6168_/A _6099_/B VDD VSS sg13cmos5l_xnor2_1
XFILLER_73_859 VDD VSS sg13cmos5l_decap_8
XFILLER_60_509 VDD VSS sg13cmos5l_fill_2
XFILLER_40_211 VDD VSS sg13cmos5l_fill_2
XFILLER_53_572 VDD VSS sg13cmos5l_decap_8
XFILLER_40_277 VDD VSS sg13cmos5l_fill_2
XFILLER_41_789 VDD VSS sg13cmos5l_decap_8
XFILLER_43_77 VDD VSS sg13cmos5l_decap_4
XFILLER_68_63 VDD VSS sg13cmos5l_fill_2
XFILLER_48_333 VDD VSS sg13cmos5l_decap_4
XFILLER_48_344 VDD VSS sg13cmos5l_fill_1
XFILLER_76_653 VDD VSS sg13cmos5l_decap_8
XFILLER_76_631 VDD VSS sg13cmos5l_decap_8
XFILLER_49_878 VDD VSS sg13cmos5l_decap_8
XFILLER_75_163 VDD VSS sg13cmos5l_decap_4
XFILLER_63_325 VDD VSS sg13cmos5l_fill_2
XFILLER_64_848 VDD VSS sg13cmos5l_decap_8
X_5470_ _5474_/A _5530_/B _5470_/B VDD VSS sg13cmos5l_xnor2_1
X_4421_ _4495_/A _4421_/A _4421_/B VDD VSS sg13cmos5l_nand2_1
X_7140_ _7141_/B _7195_/B _7296_/B VDD VSS sg13cmos5l_nor2_1
X_4352_ _4353_/B _4350_/Y _4347_/A _4351_/Y VDD VSS sg13cmos5l_o21ai_1
X_7071_ _7071_/Y _6931_/A _7071_/B VDD VSS sg13cmos5l_nand2b_1
X_4283_ _4337_/A _4283_/A _4336_/A VDD VSS sg13cmos5l_xnor2_1
XFILLER_39_300 VDD VSS sg13cmos5l_fill_1
X_6022_ _6057_/B _6022_/A _6022_/B VDD VSS sg13cmos5l_xnor2_1
XFILLER_67_642 VDD VSS sg13cmos5l_decap_4
XFILLER_67_653 VDD VSS sg13cmos5l_fill_2
Xbank_B_sram.gen_ihp_256x32.u_sram_256x32_1106 bank_B_sram.gen_ihp_256x32.u_sram_256x32_1106/L_LO
+ VDD VSS sg13cmos5l_tielo
Xbank_B_sram.gen_ihp_256x32.u_sram_256x32_1117 bank_B_sram.gen_ihp_256x32.u_sram_256x32_1117/L_LO
+ VDD VSS sg13cmos5l_tielo
Xbank_B_sram.gen_ihp_256x32.u_sram_256x32_1128 bank_B_sram.gen_ihp_256x32.u_sram_256x32_1128/L_LO
+ VDD VSS sg13cmos5l_tielo
XFILLER_66_130 VDD VSS sg13cmos5l_decap_8
XFILLER_66_152 VDD VSS sg13cmos5l_fill_1
Xbank_B_sram.gen_ihp_256x32.u_sram_256x32_1139 bank_B_sram.gen_ihp_256x32.u_sram_256x32_1139/L_LO
+ VDD VSS sg13cmos5l_tielo
XFILLER_82_601 VDD VSS sg13cmos5l_decap_8
X_6924_ _7318_/B _7219_/A _7294_/B VDD VSS sg13cmos5l_nand2_1
XFILLER_82_678 VDD VSS sg13cmos5l_decap_8
XFILLER_81_144 VDD VSS sg13cmos5l_fill_1
X_6855_ _7012_/A _6947_/A _6955_/B _6854_/X VDD VSS sg13cmos5l_a21oi_1
X_6786_ _6974_/A _6786_/A _6786_/B VDD VSS sg13cmos5l_xor2_1
X_5806_ _5863_/B _5977_/B _5806_/B VDD VSS sg13cmos5l_xnor2_1
X_5737_ _5738_/A _5737_/A VDD VSS sg13cmos5l_inv_1
X_7407_ _7500_/A _7431_/B _7407_/B VDD VSS sg13cmos5l_xnor2_1
X_5668_ _5676_/A _5668_/A _5731_/B VDD VSS sg13cmos5l_nor2b_1
X_5599_ _5600_/A _5660_/A _5599_/B VDD VSS sg13cmos5l_xnor2_1
X_4619_ _4674_/S _4675_/B1 _4493_/Y wire990/X _4920_/B2 VDD VSS sg13cmos5l_a22oi_1
X_7338_ _7338_/Y _7110_/Y _7405_/A2 _7328_/B VDD VSS sg13cmos5l_a21oi_1
X_7269_ _7269_/X _7268_/Y _7301_/A2 _7059_/Y VDD VSS sg13cmos5l_a21o_1
Xfanout942 _5622_/B1 _5557_/A1 VDD VSS sg13cmos5l_buf_1
Xrebuffer1450 rebuffer1450/X rebuffer1451/X VDD VSS sg13cmos5l_buf_1
XFILLER_58_620 VDD VSS sg13cmos5l_fill_1
Xfanout953 _6082_/A1 _5901_/B1 VDD VSS sg13cmos5l_buf_1
XFILLER_45_303 VDD VSS sg13cmos5l_fill_1
XFILLER_73_601 VDD VSS sg13cmos5l_decap_4
XFILLER_85_461 VDD VSS sg13cmos5l_fill_1
XFILLER_46_848 VDD VSS sg13cmos5l_decap_8
XFILLER_57_174 VDD VSS sg13cmos5l_fill_1
XFILLER_72_122 VDD VSS sg13cmos5l_decap_8
XFILLER_60_306 VDD VSS sg13cmos5l_fill_2
XFILLER_53_391 VDD VSS sg13cmos5l_fill_2
XFILLER_60_339 VDD VSS sg13cmos5l_fill_1
XFILLER_72_199 VDD VSS sg13cmos5l_fill_2
XFILLER_41_575 VDD VSS sg13cmos5l_fill_1
XFILLER_68_406 VDD VSS sg13cmos5l_decap_8
XFILLER_49_620 VDD VSS sg13cmos5l_fill_2
XFILLER_49_642 VDD VSS sg13cmos5l_decap_8
XFILLER_37_815 VDD VSS sg13cmos5l_fill_2
XFILLER_49_664 VDD VSS sg13cmos5l_decap_4
XFILLER_37_848 VDD VSS sg13cmos5l_decap_8
XFILLER_52_807 VDD VSS sg13cmos5l_decap_4
XFILLER_63_122 VDD VSS sg13cmos5l_decap_8
X_4970_ _5035_/A _4970_/A _4970_/B VDD VSS sg13cmos5l_nand2_1
X_6640_ _6642_/A _6641_/A _6684_/C _7699_/Q VDD VSS sg13cmos5l_a21oi_1
XFILLER_60_895 VDD VSS sg13cmos5l_decap_8
X_6571_ _6860_/A _7690_/Q _6571_/B VDD VSS sg13cmos5l_or2_1
X_5522_ _5523_/B _5395_/A _3948_/Y _5641_/B1 _3979_/Y VDD VSS sg13cmos5l_a22oi_1
X_5453_ _5453_/Y _5453_/A _5453_/B VDD VSS sg13cmos5l_nor2_1
X_5384_ _5434_/A _5442_/A _5384_/B VDD VSS sg13cmos5l_xnor2_1
X_4404_ _4404_/X _4404_/A _4404_/B VDD VSS sg13cmos5l_and2_1
X_7123_ _7151_/A _7123_/A _7123_/B _7641_/B VDD VSS sg13cmos5l_nand3_1
X_4335_ _4404_/B _4400_/B _4400_/A VDD VSS sg13cmos5l_xor2_1
XFILLER_86_203 VDD VSS sg13cmos5l_fill_2
X_7054_ _7054_/X _7054_/A _7054_/B VDD VSS sg13cmos5l_and2_1
X_4266_ _4305_/B _4266_/A _4266_/B VDD VSS sg13cmos5l_xnor2_1
XFILLER_87_759 VDD VSS sg13cmos5l_decap_8
XFILLER_74_409 VDD VSS sg13cmos5l_fill_2
X_6005_ _6007_/B _6005_/A _5964_/A VDD VSS sg13cmos5l_nor2b_1
X_4197_ _4228_/A _4180_/B _4180_/A _4196_/Y VDD VSS sg13cmos5l_a21oi_1
XFILLER_82_453 VDD VSS sg13cmos5l_fill_2
XFILLER_43_829 VDD VSS sg13cmos5l_decap_8
XFILLER_54_188 VDD VSS sg13cmos5l_fill_1
XFILLER_42_339 VDD VSS sg13cmos5l_decap_4
X_6907_ _7127_/A _6903_/Y _7046_/B _6906_/Y VDD VSS sg13cmos5l_a21oi_1
XFILLER_50_350 VDD VSS sg13cmos5l_fill_2
X_6838_ _6939_/B _6838_/A _6838_/B VDD VSS sg13cmos5l_xnor2_1
XFILLER_51_895 VDD VSS sg13cmos5l_decap_8
X_6769_ _6769_/Y _6769_/A1 _6860_/A _6573_/B VDD VSS sg13cmos5l_a21oi_1
XFILLER_40_67 VDD VSS sg13cmos5l_decap_8
XFILLER_6_4 VDD VSS sg13cmos5l_decap_8
Xclkbuf_4_0_0_clk_i_regs _7712_/CLK clkbuf_0_clk_i_regs/X VDD VSS sg13cmos5l_buf_8
XFILLER_78_704 VDD VSS sg13cmos5l_decap_8
XFILLER_78_737 VDD VSS sg13cmos5l_fill_1
Xrebuffer1280 rebuffer1280/X rebuffer1281/X VDD VSS sg13cmos5l_buf_1
Xrebuffer1291 _6722_/A1 rebuffer1331/X VDD VSS sg13cmos5l_buf_1
XFILLER_46_612 VDD VSS sg13cmos5l_fill_2
XFILLER_58_483 VDD VSS sg13cmos5l_fill_1
XFILLER_85_280 VDD VSS sg13cmos5l_fill_1
XFILLER_65_64 VDD VSS sg13cmos5l_fill_2
XFILLER_45_166 VDD VSS sg13cmos5l_fill_2
XFILLER_42_851 VDD VSS sg13cmos5l_decap_8
XFILLER_41_372 VDD VSS sg13cmos5l_fill_1
XFILLER_68_225 VDD VSS sg13cmos5l_fill_2
X_4120_ _4120_/Y _4120_/A _4120_/B VDD VSS sg13cmos5l_nor2_1
X_4051_ _4095_/A _4032_/B _4032_/A _4050_/Y VDD VSS sg13cmos5l_a21oi_1
XFILLER_77_781 VDD VSS sg13cmos5l_decap_8
XFILLER_76_280 VDD VSS sg13cmos5l_decap_8
XFILLER_80_913 VDD VSS sg13cmos5l_decap_4
XFILLER_52_659 VDD VSS sg13cmos5l_decap_4
X_4953_ _4954_/B _4953_/A _4953_/B VDD VSS sg13cmos5l_xor2_1
X_7672_ _7672_/Q clkload4/A _7672_/D place746/X VDD VSS sg13cmos5l_dfrbpq_1
X_6623_ _6631_/C _6623_/A VDD VSS sg13cmos5l_inv_1
X_4884_ _4885_/B _4646_/A _5009_/A2 _4588_/A _5140_/B2 VDD VSS sg13cmos5l_a22oi_1
X_6554_ _6869_/B _6554_/A _6554_/B VDD VSS sg13cmos5l_nand2_1
X_6485_ _6485_/Y _6485_/A _6485_/B VDD VSS sg13cmos5l_nor2_1
X_5436_ _5437_/B _5436_/A _5490_/A VDD VSS sg13cmos5l_xnor2_1
X_5367_ _5411_/A _5317_/B _5317_/A _5366_/Y VDD VSS sg13cmos5l_a21oi_1
XFILLER_59_225 VDD VSS sg13cmos5l_decap_8
XFILLER_59_236 VDD VSS sg13cmos5l_fill_1
Xinput807 input807/X bank_B_wdata[12] VDD VSS sg13cmos5l_buf_1
Xinput818 input818/X bank_B_wdata[22] VDD VSS sg13cmos5l_buf_1
Xinput829 input829/X bank_B_wdata[3] VDD VSS sg13cmos5l_buf_1
X_7106_ _7106_/Y _7106_/A VDD VSS sg13cmos5l_inv_1
X_5298_ _5299_/A _5298_/A _5233_/A VDD VSS sg13cmos5l_nor2b_1
X_4318_ _4400_/B _4318_/A _4318_/B VDD VSS sg13cmos5l_xor2_1
XFILLER_87_523 VDD VSS sg13cmos5l_decap_8
X_7037_ _7038_/A _7164_/B _7134_/B _7036_/Y VDD VSS sg13cmos5l_a21oi_1
X_4249_ _4293_/B _4249_/A _4350_/A VDD VSS sg13cmos5l_nor2_1
XFILLER_75_729 VDD VSS sg13cmos5l_decap_8
XFILLER_56_910 VDD VSS sg13cmos5l_decap_8
XFILLER_83_740 VDD VSS sg13cmos5l_decap_8
XFILLER_42_103 VDD VSS sg13cmos5l_fill_2
XFILLER_43_615 VDD VSS sg13cmos5l_fill_2
XFILLER_42_125 VDD VSS sg13cmos5l_decap_8
XFILLER_42_136 VDD VSS sg13cmos5l_fill_2
XFILLER_51_681 VDD VSS sg13cmos5l_decap_8
XFILLER_51_44 VDD VSS sg13cmos5l_fill_1
XFILLER_78_545 VDD VSS sg13cmos5l_decap_4
XFILLER_66_729 VDD VSS sg13cmos5l_decap_8
XFILLER_58_291 VDD VSS sg13cmos5l_fill_1
XFILLER_74_762 VDD VSS sg13cmos5l_decap_8
XFILLER_74_773 VDD VSS sg13cmos5l_decap_8
XFILLER_61_456 VDD VSS sg13cmos5l_decap_4
Xwire970 wire970/X wire970/A VDD VSS sg13cmos5l_buf_2
X_6270_ _6273_/A _6270_/A _6293_/B VDD VSS sg13cmos5l_nand2_2
X_5221_ _5292_/B _5221_/A _5237_/B VDD VSS sg13cmos5l_xnor2_1
X_5152_ _5153_/B _5152_/A _5152_/B VDD VSS sg13cmos5l_xor2_1
XFILLER_69_556 VDD VSS sg13cmos5l_decap_8
XFILLER_69_567 VDD VSS sg13cmos5l_fill_2
XFILLER_69_578 VDD VSS sg13cmos5l_fill_2
X_4103_ _4103_/Y _6181_/B _6181_/A VDD VSS sg13cmos5l_nand2_1
X_5083_ _5084_/B _4946_/A _5585_/A2 _4888_/A _5585_/B2 VDD VSS sg13cmos5l_a22oi_1
X_4034_ _4034_/Y _4034_/A _4010_/A VDD VSS sg13cmos5l_nor2b_1
XFILLER_84_548 VDD VSS sg13cmos5l_decap_8
XFILLER_37_453 VDD VSS sg13cmos5l_fill_1
XFILLER_53_902 VDD VSS sg13cmos5l_decap_8
XFILLER_52_412 VDD VSS sg13cmos5l_fill_2
XFILLER_52_423 VDD VSS sg13cmos5l_fill_2
X_7724_ _7724_/Q _7728_/CLK _7724_/D place752/X VDD VSS sg13cmos5l_dfrbpq_1
X_5985_ _6024_/S _6026_/B1 _6082_/A2 _5985_/B1 _6082_/B2 VDD VSS sg13cmos5l_a22oi_1
XFILLER_80_787 VDD VSS sg13cmos5l_decap_8
X_4936_ _4990_/B _5194_/A _4936_/B VDD VSS sg13cmos5l_xnor2_1
XANTENNA_10 input828/X VDD VSS sg13cmos5l_antennanp
XANTENNA_21 _6209_/Y VDD VSS sg13cmos5l_antennanp
XANTENNA_32 wire971/X VDD VSS sg13cmos5l_antennanp
X_7655_ _7656_/A _7655_/A1 _7650_/B _7177_/B VDD VSS sg13cmos5l_a21oi_1
X_4867_ _4867_/Y _4867_/A _4833_/B VDD VSS sg13cmos5l_nor2b_1
X_7586_ _7587_/B _7583_/B _7583_/A _7585_/Y VDD VSS sg13cmos5l_a21oi_1
X_6606_ _6607_/B _6614_/A _6605_/X _6598_/C VDD VSS sg13cmos5l_o21ai_1
X_6537_ _6870_/B _6537_/A _7687_/Q _6552_/C VDD VSS sg13cmos5l_nand3_1
X_4798_ _4806_/A _4741_/B _4854_/A _4798_/S VDD VSS sg13cmos5l_mux2_1
X_6468_ _6468_/X _6468_/A _6468_/B VDD VSS sg13cmos5l_and2_1
X_6399_ _6401_/A _6621_/A _6679_/B VDD VSS sg13cmos5l_nand2_1
X_5419_ _5420_/B _5419_/A _5419_/B VDD VSS sg13cmos5l_nor2_1
XFILLER_88_876 VDD VSS sg13cmos5l_fill_2
XFILLER_47_217 VDD VSS sg13cmos5l_fill_1
XFILLER_46_55 VDD VSS sg13cmos5l_decap_8
XFILLER_56_773 VDD VSS sg13cmos5l_decap_8
XFILLER_55_272 VDD VSS sg13cmos5l_fill_2
XFILLER_71_732 VDD VSS sg13cmos5l_fill_2
XFILLER_43_456 VDD VSS sg13cmos5l_decap_8
XFILLER_70_242 VDD VSS sg13cmos5l_decap_4
XFILLER_71_776 VDD VSS sg13cmos5l_fill_2
XFILLER_62_32 VDD VSS sg13cmos5l_decap_4
XFILLER_70_286 VDD VSS sg13cmos5l_fill_1
XFILLER_62_65 VDD VSS sg13cmos5l_fill_2
XFILLER_62_87 VDD VSS sg13cmos5l_decap_4
XFILLER_78_320 VDD VSS sg13cmos5l_fill_1
XFILLER_39_718 VDD VSS sg13cmos5l_decap_4
XFILLER_87_73 VDD VSS sg13cmos5l_fill_1
XFILLER_79_854 VDD VSS sg13cmos5l_decap_8
XFILLER_66_504 VDD VSS sg13cmos5l_fill_2
XFILLER_61_220 VDD VSS sg13cmos5l_fill_1
XFILLER_62_721 VDD VSS sg13cmos5l_decap_8
XFILLER_62_743 VDD VSS sg13cmos5l_decap_8
XFILLER_62_765 VDD VSS sg13cmos5l_decap_8
XFILLER_62_798 VDD VSS sg13cmos5l_decap_4
X_5770_ _5822_/B _5719_/B _5719_/A _5769_/Y VDD VSS sg13cmos5l_a21oi_1
XFILLER_61_297 VDD VSS sg13cmos5l_fill_1
X_4721_ _4721_/X _4721_/A _4721_/B VDD VSS sg13cmos5l_and2_1
X_7440_ _7441_/B _7585_/B _7436_/B _7585_/A VDD VSS sg13cmos5l_a21o_1
X_4652_ _4653_/B _4695_/A _4695_/B VDD VSS sg13cmos5l_xor2_1
X_7371_ _7373_/A _7289_/A _7226_/Y _7370_/Y VDD VSS sg13cmos5l_o21ai_1
X_4583_ _4584_/B _4642_/B1 _5009_/A2 _4583_/B1 _4642_/B2 VDD VSS sg13cmos5l_a22oi_1
X_6322_ _6621_/B _6611_/B _6483_/B VDD VSS sg13cmos5l_nand2_1
X_6253_ _6255_/B _7712_/Q _7711_/Q VDD VSS sg13cmos5l_nor2_2
X_5204_ _5207_/A _5517_/A _5205_/A _5204_/B1 VDD VSS sg13cmos5l_a21oi_1
XFILLER_88_117 VDD VSS sg13cmos5l_decap_4
XFILLER_69_331 VDD VSS sg13cmos5l_fill_1
Xrebuffer1879 _4144_/B _4143_/Y VDD VSS sg13cmos5l_buf_1
Xrebuffer1868 _4248_/A _4237_/B VDD VSS sg13cmos5l_buf_1
X_6184_ _6205_/A psum_lut_en VDD VSS sg13cmos5l_buf_1
X_5135_ _5182_/B _5194_/A _5135_/B VDD VSS sg13cmos5l_xnor2_1
XFILLER_85_835 VDD VSS sg13cmos5l_decap_8
XFILLER_84_312 VDD VSS sg13cmos5l_fill_1
XFILLER_38_740 VDD VSS sg13cmos5l_fill_1
XFILLER_57_537 VDD VSS sg13cmos5l_fill_2
X_5066_ _5067_/B _5066_/A1 _5385_/A2 _5066_/B1 _5385_/B2 VDD VSS sg13cmos5l_a22oi_1
X_4017_ _4017_/Y _5810_/B _5810_/A _4016_/Y VDD VSS sg13cmos5l_o21ai_1
XFILLER_84_389 VDD VSS sg13cmos5l_decap_8
XFILLER_37_272 VDD VSS sg13cmos5l_fill_1
XFILLER_37_294 VDD VSS sg13cmos5l_fill_2
XFILLER_52_286 VDD VSS sg13cmos5l_decap_8
X_5968_ _6015_/A _5966_/A _5927_/B _5967_/Y VDD VSS sg13cmos5l_o21ai_1
X_7707_ _7707_/Q _7712_/CLK _7707_/D place749/X VDD VSS sg13cmos5l_dfrbpq_2
X_4919_ _4927_/A _4862_/B _4854_/A _4919_/S VDD VSS sg13cmos5l_mux2_1
X_5899_ _5945_/A _5897_/B _6111_/A _5897_/Y _5898_/Y VDD VSS sg13cmos5l_a22oi_1
X_7638_ _7639_/B _7638_/A _7638_/B VDD VSS sg13cmos5l_xor2_1
X_7569_ _7573_/B _7620_/A _7620_/B _7569_/C _7569_/D VDD VSS sg13cmos5l_nor4_1
XFILLER_48_515 VDD VSS sg13cmos5l_fill_2
XFILLER_57_32 VDD VSS sg13cmos5l_fill_1
XFILLER_88_684 VDD VSS sg13cmos5l_decap_8
XFILLER_75_312 VDD VSS sg13cmos5l_decap_4
XFILLER_57_87 VDD VSS sg13cmos5l_fill_1
XFILLER_76_868 VDD VSS sg13cmos5l_decap_8
Xplace518 _6082_/B2 _4496_/Y VDD VSS sg13cmos5l_buf_1
Xplace529 _6328_/C _6275_/B VDD VSS sg13cmos5l_buf_1
XFILLER_73_42 VDD VSS sg13cmos5l_decap_8
XFILLER_43_264 VDD VSS sg13cmos5l_fill_1
XFILLER_73_75 VDD VSS sg13cmos5l_decap_4
Xoutput908 bank_B_rdata[16] output908/A VDD VSS sg13cmos5l_buf_1
Xoutput919 bank_B_rdata[26] wire967/X VDD VSS sg13cmos5l_buf_1
XFILLER_79_695 VDD VSS sg13cmos5l_decap_8
XFILLER_67_846 VDD VSS sg13cmos5l_decap_8
X_6940_ _6940_/Y _6879_/Y _6941_/B _6939_/Y VDD VSS sg13cmos5l_a21oi_1
XFILLER_47_581 VDD VSS sg13cmos5l_fill_1
XFILLER_54_529 VDD VSS sg13cmos5l_fill_1
X_6871_ _6872_/A _6871_/A _6871_/B VDD VSS sg13cmos5l_xor2_1
XFILLER_50_702 VDD VSS sg13cmos5l_fill_2
XFILLER_50_724 VDD VSS sg13cmos5l_decap_4
X_5822_ _5822_/Y _5822_/A _5822_/B VDD VSS sg13cmos5l_nor2_1
XFILLER_50_757 VDD VSS sg13cmos5l_fill_2
X_5753_ _5754_/A _5758_/A _5753_/B VDD VSS sg13cmos5l_nand2b_1
X_4704_ _4759_/A _4767_/B _4646_/A _4703_/Y VDD VSS sg13cmos5l_a21o_1
X_5684_ _5744_/S _5745_/B1 _6136_/A _5684_/B1 _4496_/Y VDD VSS sg13cmos5l_a22oi_1
X_7423_ _7432_/A _7575_/A _7574_/A _7575_/B VDD VSS sg13cmos5l_nand3_1
X_4635_ _4680_/B _4692_/A _4635_/B VDD VSS sg13cmos5l_xnor2_1
X_7354_ _7518_/A _7354_/A VDD VSS sg13cmos5l_inv_1
X_4566_ _4567_/B _4988_/A _4566_/B VDD VSS sg13cmos5l_xnor2_1
X_6305_ _6307_/A _6314_/A _6305_/B VDD VSS sg13cmos5l_xnor2_1
X_7285_ _7285_/Y _7235_/B _7171_/Y _7397_/A VDD VSS sg13cmos5l_o21ai_1
X_4497_ _4498_/B _4562_/B1 _4493_/Y _4497_/B1 _4920_/B2 VDD VSS sg13cmos5l_a22oi_1
Xclkbuf_4_5_0_clk_i_regs clkload2/A clkbuf_0_clk_i_regs/X VDD VSS sg13cmos5l_buf_8
Xhold2023 _6201_/A _7726_/Q VDD VSS sg13cmos5l_dlygate4sd3_1
X_6167_ _6168_/B _6175_/C _6175_/A VDD VSS sg13cmos5l_xnor2_1
XFILLER_58_846 VDD VSS sg13cmos5l_decap_8
XFILLER_69_194 VDD VSS sg13cmos5l_decap_8
XFILLER_85_632 VDD VSS sg13cmos5l_decap_8
XFILLER_45_507 VDD VSS sg13cmos5l_fill_1
XFILLER_57_356 VDD VSS sg13cmos5l_fill_2
X_6098_ _6099_/B _6129_/B _6129_/A VDD VSS sg13cmos5l_xnor2_1
XFILLER_73_838 VDD VSS sg13cmos5l_decap_8
X_5049_ _5057_/A _4989_/B _4967_/A _5049_/S VDD VSS sg13cmos5l_mux2_1
XFILLER_53_551 VDD VSS sg13cmos5l_fill_1
XFILLER_40_201 VDD VSS sg13cmos5l_fill_2
XFILLER_81_882 VDD VSS sg13cmos5l_decap_8
XFILLER_41_768 VDD VSS sg13cmos5l_decap_8
XFILLER_43_56 VDD VSS sg13cmos5l_decap_8
XFILLER_80_381 VDD VSS sg13cmos5l_decap_8
XFILLER_40_267 VDD VSS sg13cmos5l_fill_2
XFILLER_68_42 VDD VSS sg13cmos5l_fill_1
XFILLER_68_53 VDD VSS sg13cmos5l_fill_2
XFILLER_49_857 VDD VSS sg13cmos5l_decap_8
XFILLER_64_827 VDD VSS sg13cmos5l_decap_8
XFILLER_63_315 VDD VSS sg13cmos5l_decap_4
XFILLER_44_540 VDD VSS sg13cmos5l_decap_4
XFILLER_84_96 VDD VSS sg13cmos5l_decap_4
XFILLER_44_573 VDD VSS sg13cmos5l_decap_8
XFILLER_72_893 VDD VSS sg13cmos5l_decap_8
XFILLER_44_595 VDD VSS sg13cmos5l_decap_8
XFILLER_71_381 VDD VSS sg13cmos5l_decap_8
X_4420_ _4421_/B _6110_/B _4494_/A VDD VSS sg13cmos5l_nand2_1
X_4351_ _4351_/Y _4351_/A _4351_/B VDD VSS sg13cmos5l_nand2_1
X_7070_ _7070_/Y _7069_/B _6928_/Y _7069_/Y VDD VSS sg13cmos5l_o21ai_1
X_4282_ _4336_/A _4282_/A _4282_/B VDD VSS sg13cmos5l_xor2_1
X_6021_ _6022_/B _6136_/B _6021_/A2 _6084_/B1 _6021_/B2 VDD VSS sg13cmos5l_a22oi_1
Xbank_B_sram.gen_ihp_256x32.u_sram_256x32_1107 bank_B_sram.gen_ihp_256x32.u_sram_256x32_1107/L_LO
+ VDD VSS sg13cmos5l_tielo
Xbank_B_sram.gen_ihp_256x32.u_sram_256x32_1118 bank_B_sram.gen_ihp_256x32.u_sram_256x32_1118/L_LO
+ VDD VSS sg13cmos5l_tielo
Xbank_B_sram.gen_ihp_256x32.u_sram_256x32_1129 bank_B_sram.gen_ihp_256x32.u_sram_256x32_1129/L_LO
+ VDD VSS sg13cmos5l_tielo
XFILLER_39_378 VDD VSS sg13cmos5l_fill_2
XFILLER_66_175 VDD VSS sg13cmos5l_decap_4
XFILLER_70_819 VDD VSS sg13cmos5l_decap_8
X_6923_ _7219_/A _7006_/B _7132_/A _6922_/Y VDD VSS sg13cmos5l_o21ai_1
XFILLER_82_657 VDD VSS sg13cmos5l_decap_8
XFILLER_63_882 VDD VSS sg13cmos5l_decap_8
XFILLER_81_189 VDD VSS sg13cmos5l_fill_1
X_6854_ _6854_/X _6955_/A _6968_/B VDD VSS sg13cmos5l_and2_1
XFILLER_50_554 VDD VSS sg13cmos5l_decap_8
X_5805_ _5806_/B _5871_/B1 _5871_/A2 _5805_/B1 _5871_/B2 VDD VSS sg13cmos5l_a22oi_1
X_5736_ _5786_/A _5736_/A _5736_/B _5736_/C VDD VSS sg13cmos5l_nand3_1
X_5667_ _5731_/B _5667_/A _5667_/B _5667_/C VDD VSS sg13cmos5l_nand3_1
X_7406_ _7407_/B _7376_/A _7295_/Y _7405_/Y VDD VSS sg13cmos5l_o21ai_1
X_4618_ _4626_/A _4567_/B _4854_/A _4618_/S VDD VSS sg13cmos5l_mux2_1
X_5598_ _5599_/B _5598_/A _5598_/B VDD VSS sg13cmos5l_xor2_1
X_7337_ _7342_/A _7525_/A _7524_/B _7525_/B VDD VSS sg13cmos5l_nand3_1
X_4549_ _4668_/B _4549_/A _4544_/A VDD VSS sg13cmos5l_nor2b_1
X_7268_ _7268_/Y _7107_/Y _7233_/B _7182_/A VDD VSS sg13cmos5l_a21oi_1
Xfanout943 _5684_/B1 _5558_/B1 VDD VSS sg13cmos5l_buf_1
Xrebuffer1451 rebuffer1451/X rebuffer1452/X VDD VSS sg13cmos5l_buf_2
Xrebuffer1440 rebuffer1440/X rebuffer1441/X VDD VSS sg13cmos5l_buf_1
X_6219_ _6219_/Y _6223_/A _6219_/B VDD VSS sg13cmos5l_nand2_1
XFILLER_77_429 VDD VSS sg13cmos5l_decap_8
XFILLER_77_418 VDD VSS sg13cmos5l_fill_2
Xfanout954 _6084_/B1 _6114_/B VDD VSS sg13cmos5l_buf_1
X_7199_ _7201_/A _6630_/A _7356_/A _7198_/Y VDD VSS sg13cmos5l_o21ai_1
XFILLER_39_890 VDD VSS sg13cmos5l_decap_8
XFILLER_46_827 VDD VSS sg13cmos5l_decap_8
XFILLER_73_635 VDD VSS sg13cmos5l_decap_8
XFILLER_45_348 VDD VSS sg13cmos5l_fill_2
XFILLER_73_668 VDD VSS sg13cmos5l_decap_8
XFILLER_54_55 VDD VSS sg13cmos5l_fill_2
XFILLER_70_87 VDD VSS sg13cmos5l_decap_8
XFILLER_68_418 VDD VSS sg13cmos5l_fill_2
XFILLER_48_153 VDD VSS sg13cmos5l_decap_8
XFILLER_37_827 VDD VSS sg13cmos5l_fill_1
XFILLER_37_838 VDD VSS sg13cmos5l_fill_2
XFILLER_64_624 VDD VSS sg13cmos5l_decap_8
XFILLER_63_145 VDD VSS sg13cmos5l_fill_1
XFILLER_64_646 VDD VSS sg13cmos5l_fill_1
XFILLER_51_307 VDD VSS sg13cmos5l_decap_8
XFILLER_51_329 VDD VSS sg13cmos5l_decap_8
XFILLER_60_874 VDD VSS sg13cmos5l_decap_8
X_6570_ _6573_/B _7691_/Q _6570_/B VDD VSS sg13cmos5l_xnor2_1
X_5521_ _5579_/B _5518_/Y _5460_/A _5520_/Y VDD VSS sg13cmos5l_a21oi_1
X_5452_ _5468_/A _5452_/A _5452_/B VDD VSS sg13cmos5l_xor2_1
X_5383_ _5384_/B _5909_/B1 _5869_/A2 _5859_/B1 _5869_/B2 VDD VSS sg13cmos5l_a22oi_1
X_4403_ _4414_/B _4403_/A _4403_/B VDD VSS sg13cmos5l_xor2_1
X_7122_ _7641_/B _7716_/Q _7122_/B VDD VSS sg13cmos5l_nand2b_1
X_4334_ _4400_/A _4334_/A _4399_/A VDD VSS sg13cmos5l_xnor2_1
X_7053_ _7191_/A _6917_/Y _7069_/B _7052_/X VDD VSS sg13cmos5l_a21o_1
XFILLER_87_738 VDD VSS sg13cmos5l_decap_8
X_6004_ _6007_/C _6004_/A _6004_/B VDD VSS sg13cmos5l_nand2_1
X_4265_ _4266_/B _4565_/B1 _4378_/A2 _3964_/C _4378_/B2 VDD VSS sg13cmos5l_a22oi_1
XFILLER_86_215 VDD VSS sg13cmos5l_fill_1
X_4196_ _4196_/Y _4196_/A _4196_/B_N VDD VSS sg13cmos5l_nor2b_1
XFILLER_67_462 VDD VSS sg13cmos5l_fill_1
XFILLER_43_808 VDD VSS sg13cmos5l_decap_8
XFILLER_82_465 VDD VSS sg13cmos5l_fill_1
X_6906_ _6906_/Y _7004_/A _6906_/B VDD VSS sg13cmos5l_nor2_1
XFILLER_51_874 VDD VSS sg13cmos5l_decap_8
Xplace690 _7006_/B _7030_/B VDD VSS sg13cmos5l_buf_1
X_6837_ _6838_/B _6837_/A _6837_/B VDD VSS sg13cmos5l_nand2_1
XFILLER_40_24 VDD VSS sg13cmos5l_decap_8
X_6699_ _6700_/B _6699_/A VDD VSS sg13cmos5l_inv_1
X_5719_ _5742_/B _5719_/A _5719_/B VDD VSS sg13cmos5l_xnor2_1
Xrebuffer1270 _6799_/A _6286_/B VDD VSS sg13cmos5l_buf_1
XFILLER_78_749 VDD VSS sg13cmos5l_fill_1
XFILLER_1_18 VDD VSS sg13cmos5l_fill_2
Xrebuffer1281 rebuffer1281/X rebuffer1282/X VDD VSS sg13cmos5l_buf_1
Xrebuffer1292 _6743_/A _6670_/A VDD VSS sg13cmos5l_buf_1
XFILLER_58_462 VDD VSS sg13cmos5l_decap_8
XFILLER_65_32 VDD VSS sg13cmos5l_decap_8
XFILLER_45_123 VDD VSS sg13cmos5l_decap_8
XFILLER_46_668 VDD VSS sg13cmos5l_decap_4
XFILLER_42_830 VDD VSS sg13cmos5l_decap_8
XFILLER_81_53 VDD VSS sg13cmos5l_fill_1
Xmax_cap1013 _4326_/A _4642_/B1 VDD VSS sg13cmos5l_buf_2
XFILLER_68_204 VDD VSS sg13cmos5l_decap_8
XFILLER_68_259 VDD VSS sg13cmos5l_decap_4
X_4050_ _4050_/Y _4050_/A _4050_/B VDD VSS sg13cmos5l_nor2_1
XFILLER_52_627 VDD VSS sg13cmos5l_decap_8
XFILLER_64_487 VDD VSS sg13cmos5l_fill_2
X_4952_ _4953_/B _5007_/A _5007_/B VDD VSS sg13cmos5l_xor2_1
X_7671_ _7671_/Q clkload4/A _7671_/D place746/X VDD VSS sg13cmos5l_dfrbpq_1
X_4883_ _4928_/A _4832_/B _4832_/A _4882_/Y VDD VSS sg13cmos5l_a21oi_1
X_6622_ _6622_/Y _6623_/A _6631_/B VDD VSS sg13cmos5l_nor2b_1
X_6553_ _6555_/B _6553_/A _6861_/B VDD VSS sg13cmos5l_nor2b_1
X_6484_ _6491_/A _6484_/A _6485_/A VDD VSS sg13cmos5l_nor2b_2
X_5504_ _5511_/A _5630_/A _5504_/B VDD VSS sg13cmos5l_xnor2_1
X_5435_ _5490_/A _5388_/B _5388_/A _5434_/X VDD VSS sg13cmos5l_a21oi_1
XFILLER_59_204 VDD VSS sg13cmos5l_decap_4
X_5366_ _5366_/Y _5366_/A _5366_/B VDD VSS sg13cmos5l_nor2_1
XFILLER_87_502 VDD VSS sg13cmos5l_decap_8
Xinput808 input808/X bank_B_wdata[13] VDD VSS sg13cmos5l_buf_1
Xinput819 input819/X bank_B_wdata[23] VDD VSS sg13cmos5l_buf_1
X_7105_ _7106_/A _7105_/A _7105_/B VDD VSS sg13cmos5l_nand2_1
X_5297_ _5360_/B _5297_/A _5359_/A VDD VSS sg13cmos5l_xnor2_1
X_4317_ _4318_/B _4369_/A _4369_/B VDD VSS sg13cmos5l_xor2_1
XFILLER_68_760 VDD VSS sg13cmos5l_decap_8
X_7036_ _7036_/Y _7184_/B _7170_/A VDD VSS sg13cmos5l_nor2_1
X_4248_ _4249_/A _4248_/A _4237_/A VDD VSS sg13cmos5l_nor2b_1
X_4179_ _4180_/B _4179_/A _4196_/A VDD VSS sg13cmos5l_xnor2_1
XFILLER_55_454 VDD VSS sg13cmos5l_decap_8
XFILLER_71_914 VDD VSS sg13cmos5l_decap_4
XFILLER_70_424 VDD VSS sg13cmos5l_fill_1
XFILLER_83_796 VDD VSS sg13cmos5l_decap_8
XFILLER_82_273 VDD VSS sg13cmos5l_decap_8
XFILLER_51_67 VDD VSS sg13cmos5l_fill_2
XFILLER_78_535 VDD VSS sg13cmos5l_decap_4
XFILLER_47_900 VDD VSS sg13cmos5l_decap_8
XFILLER_59_771 VDD VSS sg13cmos5l_decap_4
XFILLER_41_170 VDD VSS sg13cmos5l_decap_4
XFILLER_41_181 VDD VSS sg13cmos5l_fill_1
Xwire971 wire971/X wire971/A VDD VSS sg13cmos5l_buf_2
Xwire982 wire982/X wire982/A VDD VSS sg13cmos5l_buf_4
Xwire993 _5274_/A wire993/A VDD VSS sg13cmos5l_buf_2
X_5220_ _5237_/B _5238_/B _5238_/A VDD VSS sg13cmos5l_xor2_1
X_5151_ _5152_/B _5197_/A _5197_/B VDD VSS sg13cmos5l_xor2_1
XFILLER_57_708 VDD VSS sg13cmos5l_fill_2
XFILLER_57_719 VDD VSS sg13cmos5l_fill_2
X_4102_ _6181_/A _4040_/A _4102_/B VDD VSS sg13cmos5l_nand2b_1
X_4033_ _4033_/Y _4033_/A VDD VSS sg13cmos5l_inv_1
XFILLER_37_410 VDD VSS sg13cmos5l_fill_2
XFILLER_37_421 VDD VSS sg13cmos5l_decap_8
XFILLER_77_590 VDD VSS sg13cmos5l_decap_8
XFILLER_112_18 VDD VSS sg13cmos5l_fill_2
XFILLER_64_251 VDD VSS sg13cmos5l_decap_4
XFILLER_80_733 VDD VSS sg13cmos5l_decap_4
X_7723_ _7723_/Q clkload6/A _7723_/D place752/X VDD VSS sg13cmos5l_dfrbpq_1
X_5984_ _5993_/A _5952_/B _5788_/A _5984_/S VDD VSS sg13cmos5l_mux2_1
XFILLER_80_766 VDD VSS sg13cmos5l_decap_8
X_4935_ _4936_/B _5370_/B1 _5385_/A2 _5310_/B1 _5385_/B2 VDD VSS sg13cmos5l_a22oi_1
XANTENNA_11 _7710_/D VDD VSS sg13cmos5l_antennanp
XANTENNA_22 input809/X VDD VSS sg13cmos5l_antennanp
X_7654_ _7726_/D _7654_/A _7658_/B VDD VSS sg13cmos5l_nand2_2
X_4866_ _4958_/A _4866_/A _4866_/B VDD VSS sg13cmos5l_xor2_1
XANTENNA_33 input764/X VDD VSS sg13cmos5l_antennanp
X_7585_ _7585_/Y _7585_/A _7585_/B VDD VSS sg13cmos5l_nor2_1
X_6605_ _6605_/X _6605_/A _6605_/B VDD VSS sg13cmos5l_and2_1
X_4797_ _4905_/A _4745_/B _4745_/A _4796_/Y VDD VSS sg13cmos5l_a21oi_1
XFILLER_21_15 VDD VSS sg13cmos5l_decap_4
X_6536_ _6538_/A _6537_/A _6552_/C _7687_/Q VDD VSS sg13cmos5l_a21oi_1
X_6467_ _6476_/A _6468_/B _6468_/A VDD VSS sg13cmos5l_nor2_2
X_6398_ _6679_/B _6541_/B _6698_/A VDD VSS sg13cmos5l_and2_1
X_5418_ _5419_/B _5546_/A _5418_/B VDD VSS sg13cmos5l_nor2_1
X_5349_ _5350_/B _5349_/A _5349_/B VDD VSS sg13cmos5l_xor2_1
XFILLER_87_321 VDD VSS sg13cmos5l_fill_1
XFILLER_87_332 VDD VSS sg13cmos5l_fill_1
XFILLER_48_719 VDD VSS sg13cmos5l_decap_8
XFILLER_46_12 VDD VSS sg13cmos5l_fill_1
XFILLER_68_590 VDD VSS sg13cmos5l_decap_8
X_7019_ _7020_/A _7085_/B _6794_/A _7018_/Y VDD VSS sg13cmos5l_o21ai_1
XFILLER_75_549 VDD VSS sg13cmos5l_fill_1
XFILLER_55_240 VDD VSS sg13cmos5l_decap_8
XFILLER_55_295 VDD VSS sg13cmos5l_fill_1
XFILLER_83_593 VDD VSS sg13cmos5l_decap_8
XFILLER_62_44 VDD VSS sg13cmos5l_fill_2
XFILLER_87_52 VDD VSS sg13cmos5l_fill_1
XFILLER_79_833 VDD VSS sg13cmos5l_decap_8
XFILLER_38_207 VDD VSS sg13cmos5l_decap_8
XFILLER_87_96 VDD VSS sg13cmos5l_fill_1
XFILLER_46_240 VDD VSS sg13cmos5l_decap_8
XFILLER_74_560 VDD VSS sg13cmos5l_decap_8
X_4720_ _4785_/B _4720_/A _4730_/A VDD VSS sg13cmos5l_xor2_1
X_4651_ _4695_/B _5018_/A _4651_/B VDD VSS sg13cmos5l_xnor2_1
X_7370_ _7370_/Y _7370_/A _7377_/B VDD VSS sg13cmos5l_nor2_1
X_4582_ _4627_/A _4534_/B _4534_/A _4581_/Y VDD VSS sg13cmos5l_a21oi_1
X_6321_ _6483_/B _6407_/B _6321_/B _6548_/C VDD VSS sg13cmos5l_nor3_1
X_6252_ _6802_/A _7706_/Q _6258_/A VDD VSS sg13cmos5l_xnor2_1
X_6183_ _6183_/Y _6183_/A VDD VSS sg13cmos5l_inv_1
Xrebuffer1869 _4236_/B _4186_/A VDD VSS sg13cmos5l_buf_1
X_5134_ _5135_/B _5193_/B1 _5385_/A2 _5493_/B1 _5385_/B2 VDD VSS sg13cmos5l_a22oi_1
XFILLER_85_814 VDD VSS sg13cmos5l_decap_8
XFILLER_69_398 VDD VSS sg13cmos5l_decap_8
X_5065_ _5123_/A _5442_/A _5065_/B VDD VSS sg13cmos5l_xnor2_1
XFILLER_72_508 VDD VSS sg13cmos5l_decap_8
X_4016_ _4016_/Y _5811_/B _5810_/B VDD VSS sg13cmos5l_nand2_1
XFILLER_16_15 VDD VSS sg13cmos5l_decap_4
XFILLER_53_733 VDD VSS sg13cmos5l_decap_8
XFILLER_41_917 VDD VSS sg13cmos5l_fill_1
XFILLER_52_221 VDD VSS sg13cmos5l_decap_8
XFILLER_53_766 VDD VSS sg13cmos5l_decap_8
X_5967_ _5967_/Y _5967_/A _5967_/B VDD VSS sg13cmos5l_nand2_1
X_7706_ _7706_/Q clkload8/A _7706_/D place753/X VDD VSS sg13cmos5l_dfrbpq_1
X_4918_ _4962_/A _4967_/A _4981_/B VDD VSS sg13cmos5l_xnor2_1
X_7637_ _7722_/D _7637_/A _7658_/B VDD VSS sg13cmos5l_nand2_2
X_5898_ _5898_/Y _6111_/A _5898_/B VDD VSS sg13cmos5l_nor2_1
X_4849_ _7679_/D _4849_/A _4849_/B VDD VSS sg13cmos5l_xnor2_1
X_7568_ _7569_/D _7621_/A VDD VSS sg13cmos5l_inv_1
X_7499_ _7624_/C _7497_/Y _7499_/B VDD VSS sg13cmos5l_nand2b_1
X_6519_ _6519_/Y _6519_/A _6518_/A VDD VSS sg13cmos5l_nor2b_1
XFILLER_88_652 VDD VSS sg13cmos5l_fill_1
XFILLER_48_505 VDD VSS sg13cmos5l_fill_1
XFILLER_88_663 VDD VSS sg13cmos5l_fill_1
XFILLER_76_847 VDD VSS sg13cmos5l_decap_8
Xplace519 _4920_/B2 _5370_/B2 VDD VSS sg13cmos5l_buf_1
XFILLER_84_891 VDD VSS sg13cmos5l_decap_8
XFILLER_43_232 VDD VSS sg13cmos5l_decap_8
XFILLER_43_243 VDD VSS sg13cmos5l_fill_1
XFILLER_73_32 VDD VSS sg13cmos5l_fill_1
XFILLER_44_799 VDD VSS sg13cmos5l_decap_8
XFILLER_71_563 VDD VSS sg13cmos5l_fill_1
XFILLER_71_574 VDD VSS sg13cmos5l_fill_1
Xoutput909 bank_B_rdata[17] output909/A VDD VSS sg13cmos5l_buf_1
XFILLER_39_516 VDD VSS sg13cmos5l_fill_1
XFILLER_67_803 VDD VSS sg13cmos5l_fill_1
XFILLER_67_825 VDD VSS sg13cmos5l_decap_8
XFILLER_79_674 VDD VSS sg13cmos5l_decap_8
XFILLER_54_508 VDD VSS sg13cmos5l_fill_1
XFILLER_81_305 VDD VSS sg13cmos5l_fill_1
XFILLER_82_839 VDD VSS sg13cmos5l_decap_8
XFILLER_75_891 VDD VSS sg13cmos5l_decap_8
XFILLER_74_390 VDD VSS sg13cmos5l_decap_4
X_6870_ _6871_/B _6870_/A _6870_/B VDD VSS sg13cmos5l_nand2_1
X_5821_ _5821_/Y _5822_/B _5822_/A VDD VSS sg13cmos5l_nand2_1
XFILLER_50_747 VDD VSS sg13cmos5l_decap_4
X_5752_ _5772_/A _5752_/A _5752_/B VDD VSS sg13cmos5l_xor2_1
X_4703_ _4703_/Y _4703_/A _4703_/B VDD VSS sg13cmos5l_nor2_1
X_7422_ _7575_/B _7417_/B _7438_/A VDD VSS sg13cmos5l_nand2b_1
X_4634_ _4635_/B _5050_/B1 _4878_/A2 _4986_/B1 _4878_/B2 VDD VSS sg13cmos5l_a22oi_1
X_7353_ _7354_/A _7360_/B _7353_/B VDD VSS sg13cmos5l_nor2_1
X_4565_ _4566_/B _4620_/B1 _4303_/A _4565_/B1 _4800_/B2 VDD VSS sg13cmos5l_a22oi_1
X_6304_ _6314_/A _6323_/A _6602_/B VDD VSS sg13cmos5l_nor2_1
X_7284_ _7284_/Y _7284_/A VDD VSS sg13cmos5l_inv_1
X_4496_ _4496_/Y _4496_/A VDD VSS sg13cmos5l_inv_1
X_6235_ _6255_/C _7709_/Q VDD VSS sg13cmos5l_inv_4
XFILLER_69_140 VDD VSS sg13cmos5l_fill_1
Xhold2024 _7611_/A _7713_/Q VDD VSS sg13cmos5l_dlygate4sd3_1
X_6166_ _6175_/A _6166_/A _6147_/A VDD VSS sg13cmos5l_nor2b_1
XFILLER_85_611 VDD VSS sg13cmos5l_decap_8
XFILLER_57_313 VDD VSS sg13cmos5l_fill_2
X_6097_ _6129_/A _6097_/A _6070_/A VDD VSS sg13cmos5l_nor2b_1
X_5117_ _5177_/S _5178_/B1 _5493_/A2 _5117_/B1 _5370_/B2 VDD VSS sg13cmos5l_a22oi_1
XFILLER_57_368 VDD VSS sg13cmos5l_fill_2
XFILLER_73_817 VDD VSS sg13cmos5l_decap_8
X_5048_ _5095_/A _5048_/A _5171_/B VDD VSS sg13cmos5l_xnor2_1
XFILLER_66_880 VDD VSS sg13cmos5l_decap_8
XFILLER_72_327 VDD VSS sg13cmos5l_decap_8
XFILLER_85_688 VDD VSS sg13cmos5l_decap_8
XFILLER_53_541 VDD VSS sg13cmos5l_fill_1
XFILLER_41_725 VDD VSS sg13cmos5l_fill_1
XFILLER_81_861 VDD VSS sg13cmos5l_decap_8
XFILLER_40_213 VDD VSS sg13cmos5l_fill_1
XFILLER_43_46 VDD VSS sg13cmos5l_fill_2
X_6999_ _7233_/C _7154_/A _7162_/B VDD VSS sg13cmos5l_nand2_1
XFILLER_49_836 VDD VSS sg13cmos5l_decap_8
XFILLER_68_98 VDD VSS sg13cmos5l_decap_8
XFILLER_64_806 VDD VSS sg13cmos5l_fill_1
XFILLER_76_688 VDD VSS sg13cmos5l_decap_8
XFILLER_44_530 VDD VSS sg13cmos5l_fill_1
XFILLER_72_872 VDD VSS sg13cmos5l_decap_8
X_4350_ _4350_/Y _4350_/A VDD VSS sg13cmos5l_inv_1
X_4281_ _4282_/B _4319_/A _4319_/B VDD VSS sg13cmos5l_xor2_1
X_6020_ _6067_/A _5993_/B _5993_/A _6019_/Y VDD VSS sg13cmos5l_a21oi_1
Xbank_B_sram.gen_ihp_256x32.u_sram_256x32_1108 bank_B_sram.gen_ihp_256x32.u_sram_256x32_1108/L_LO
+ VDD VSS sg13cmos5l_tielo
Xbank_B_sram.gen_ihp_256x32.u_sram_256x32_1119 bank_B_sram.gen_ihp_256x32.u_sram_256x32_1119/L_LO
+ VDD VSS sg13cmos5l_tielo
XFILLER_39_357 VDD VSS sg13cmos5l_fill_2
XFILLER_66_121 VDD VSS sg13cmos5l_fill_2
XFILLER_67_655 VDD VSS sg13cmos5l_fill_1
XFILLER_67_666 VDD VSS sg13cmos5l_fill_2
XFILLER_48_891 VDD VSS sg13cmos5l_decap_8
XFILLER_55_839 VDD VSS sg13cmos5l_decap_8
XFILLER_67_699 VDD VSS sg13cmos5l_decap_8
XFILLER_82_636 VDD VSS sg13cmos5l_decap_8
XFILLER_81_102 VDD VSS sg13cmos5l_decap_4
X_6922_ _6922_/Y _6922_/A _7006_/B VDD VSS sg13cmos5l_nand2_1
XFILLER_63_861 VDD VSS sg13cmos5l_decap_8
X_6853_ _6955_/A _6853_/A _6438_/A VDD VSS sg13cmos5l_nor2b_1
XFILLER_81_157 VDD VSS sg13cmos5l_fill_2
X_5804_ _5863_/A _5870_/A _5804_/B VDD VSS sg13cmos5l_xnor2_1
X_6784_ _6894_/B _6784_/A _7059_/A VDD VSS sg13cmos5l_nand2_1
X_3996_ _3996_/Y _5811_/B _5810_/A VDD VSS sg13cmos5l_nor2b_1
XFILLER_13_16 VDD VSS sg13cmos5l_decap_4
XFILLER_50_588 VDD VSS sg13cmos5l_fill_1
X_5735_ _7693_/D _5735_/A _5735_/B VDD VSS sg13cmos5l_xnor2_1
X_5666_ _5668_/A _5667_/A _5667_/C _5667_/B VDD VSS sg13cmos5l_a21oi_1
X_7405_ _7405_/Y _7300_/Y _7405_/A2 _7377_/B VDD VSS sg13cmos5l_a21oi_1
X_4617_ _4718_/A _4571_/B _4571_/A _4616_/X VDD VSS sg13cmos5l_a21oi_1
X_5597_ _5598_/B _5597_/A _5597_/B VDD VSS sg13cmos5l_nand2_1
X_7336_ _7525_/B _7336_/A _7360_/B VDD VSS sg13cmos5l_nand2_1
X_4548_ _7674_/D _4548_/A _4548_/B_N VDD VSS sg13cmos5l_nor2b_1
X_7267_ _7267_/Y _7299_/A1 _7263_/Y _7266_/Y VDD VSS sg13cmos5l_o21ai_1
X_4479_ _4547_/A _4479_/A _4479_/B _4479_/C VDD VSS sg13cmos5l_nand3_1
Xfanout933 _4303_/B _4497_/B1 VDD VSS sg13cmos5l_buf_1
Xrebuffer1452 rebuffer1452/X rebuffer1453/X VDD VSS sg13cmos5l_buf_1
Xrebuffer1441 rebuffer1441/X rebuffer1442/X VDD VSS sg13cmos5l_buf_1
Xrebuffer1430 rebuffer1430/X rebuffer1431/X VDD VSS sg13cmos5l_buf_1
X_6218_ _6218_/Y _6210_/A _6192_/Y _6217_/Y VDD VSS sg13cmos5l_o21ai_1
XFILLER_58_633 VDD VSS sg13cmos5l_decap_4
Xfanout944 _5745_/B1 _5558_/A1 VDD VSS sg13cmos5l_buf_1
Xfanout955 _4565_/B1 _4675_/B1 VDD VSS sg13cmos5l_buf_1
X_7198_ _7198_/Y _7274_/A _7197_/Y _7290_/A VDD VSS sg13cmos5l_a21oi_1
X_6149_ _6149_/Y _6149_/A _6149_/B VDD VSS sg13cmos5l_nand2_1
XFILLER_72_146 VDD VSS sg13cmos5l_fill_2
XFILLER_53_360 VDD VSS sg13cmos5l_decap_8
XFILLER_72_157 VDD VSS sg13cmos5l_decap_4
XFILLER_54_894 VDD VSS sg13cmos5l_decap_8
XFILLER_80_190 VDD VSS sg13cmos5l_fill_2
XFILLER_41_599 VDD VSS sg13cmos5l_fill_2
XFILLER_70_33 VDD VSS sg13cmos5l_decap_4
XFILLER_70_44 VDD VSS sg13cmos5l_decap_8
XFILLER_79_42 VDD VSS sg13cmos5l_fill_2
XFILLER_49_622 VDD VSS sg13cmos5l_fill_1
XFILLER_88_290 VDD VSS sg13cmos5l_decap_4
XFILLER_64_603 VDD VSS sg13cmos5l_fill_2
XFILLER_48_187 VDD VSS sg13cmos5l_decap_8
XFILLER_45_883 VDD VSS sg13cmos5l_decap_8
XFILLER_72_680 VDD VSS sg13cmos5l_decap_8
XFILLER_60_853 VDD VSS sg13cmos5l_decap_8
XFILLER_71_190 VDD VSS sg13cmos5l_fill_2
XFILLER_81_4 VDD VSS sg13cmos5l_fill_1
X_5520_ _5520_/Y _5520_/A VDD VSS sg13cmos5l_inv_1
X_5451_ _5452_/B _5497_/A _5497_/B VDD VSS sg13cmos5l_xor2_1
X_4402_ _4403_/B _4461_/B _4461_/A VDD VSS sg13cmos5l_xor2_1
X_7121_ _7123_/B _7717_/Q _7150_/A VDD VSS sg13cmos5l_xor2_1
X_4333_ _4399_/A _4333_/A _4333_/B VDD VSS sg13cmos5l_xor2_1
XFILLER_115_18 VDD VSS sg13cmos5l_fill_2
X_7052_ _7052_/X _7052_/A _7054_/B VDD VSS sg13cmos5l_and2_1
X_4264_ _4305_/A _4312_/A _4264_/B VDD VSS sg13cmos5l_xnor2_1
XFILLER_87_717 VDD VSS sg13cmos5l_decap_8
X_6003_ _6007_/A _6073_/A VDD VSS sg13cmos5l_inv_1
X_4195_ _4252_/A _4374_/A _4251_/B VDD VSS sg13cmos5l_xnor2_1
XFILLER_83_901 VDD VSS sg13cmos5l_decap_8
XFILLER_39_154 VDD VSS sg13cmos5l_fill_1
XFILLER_55_636 VDD VSS sg13cmos5l_fill_2
XFILLER_55_658 VDD VSS sg13cmos5l_decap_8
XFILLER_67_496 VDD VSS sg13cmos5l_decap_8
XFILLER_42_319 VDD VSS sg13cmos5l_decap_8
XFILLER_70_617 VDD VSS sg13cmos5l_decap_8
X_6905_ _6906_/B _6741_/Y _6901_/A _6904_/Y VDD VSS sg13cmos5l_a21oi_1
XFILLER_82_455 VDD VSS sg13cmos5l_fill_1
XFILLER_63_691 VDD VSS sg13cmos5l_fill_2
XFILLER_50_352 VDD VSS sg13cmos5l_fill_1
XFILLER_51_853 VDD VSS sg13cmos5l_decap_8
Xplace680 _7276_/S _6891_/B VDD VSS sg13cmos5l_buf_1
Xplace691 _7030_/B _7164_/A VDD VSS sg13cmos5l_buf_1
X_6836_ _6838_/A _6836_/A _6836_/B VDD VSS sg13cmos5l_nand2_1
XFILLER_50_363 VDD VSS sg13cmos5l_fill_2
X_6767_ _7001_/A _6764_/Y _6929_/B _6766_/X VDD VSS sg13cmos5l_a21oi_1
X_5718_ _5719_/B _5718_/A _5769_/A VDD VSS sg13cmos5l_xnor2_1
X_3979_ _3979_/Y _5645_/A _3947_/A _3978_/Y VDD VSS sg13cmos5l_o21ai_1
X_6698_ _6699_/A _6698_/A _6698_/B VDD VSS sg13cmos5l_nor2_1
X_5649_ _5652_/A _5649_/A _5649_/B VDD VSS sg13cmos5l_xor2_1
X_7319_ _7320_/A _7327_/A _7319_/B VDD VSS sg13cmos5l_nor2_1
XFILLER_49_34 VDD VSS sg13cmos5l_fill_1
XFILLER_77_205 VDD VSS sg13cmos5l_decap_8
XFILLER_49_56 VDD VSS sg13cmos5l_decap_8
Xrebuffer1260 _6976_/B _6248_/A VDD VSS sg13cmos5l_buf_1
Xrebuffer1271 rebuffer1271/X rebuffer1272/X VDD VSS sg13cmos5l_buf_1
XFILLER_77_227 VDD VSS sg13cmos5l_fill_2
XFILLER_58_430 VDD VSS sg13cmos5l_fill_2
XFILLER_58_441 VDD VSS sg13cmos5l_decap_8
Xrebuffer1282 rebuffer1282/X rebuffer1283/X VDD VSS sg13cmos5l_buf_1
Xrebuffer1293 rebuffer1293/X rebuffer1294/X VDD VSS sg13cmos5l_buf_1
XFILLER_77_249 VDD VSS sg13cmos5l_decap_8
XFILLER_86_794 VDD VSS sg13cmos5l_decap_8
XFILLER_46_647 VDD VSS sg13cmos5l_decap_8
XFILLER_65_55 VDD VSS sg13cmos5l_decap_4
XFILLER_65_66 VDD VSS sg13cmos5l_fill_1
XFILLER_61_639 VDD VSS sg13cmos5l_decap_8
XFILLER_42_886 VDD VSS sg13cmos5l_decap_8
XFILLER_53_8 VDD VSS sg13cmos5l_fill_2
XFILLER_69_717 VDD VSS sg13cmos5l_fill_1
XFILLER_69_728 VDD VSS sg13cmos5l_decap_8
XFILLER_84_709 VDD VSS sg13cmos5l_decap_8
XFILLER_77_750 VDD VSS sg13cmos5l_fill_2
XFILLER_37_603 VDD VSS sg13cmos5l_fill_2
XFILLER_37_614 VDD VSS sg13cmos5l_decap_8
XFILLER_37_625 VDD VSS sg13cmos5l_decap_4
XFILLER_64_400 VDD VSS sg13cmos5l_fill_1
XFILLER_77_761 VDD VSS sg13cmos5l_fill_1
XFILLER_76_260 VDD VSS sg13cmos5l_fill_2
XFILLER_64_422 VDD VSS sg13cmos5l_decap_8
XFILLER_51_127 VDD VSS sg13cmos5l_fill_2
X_4951_ _5007_/B _5018_/A _4951_/B VDD VSS sg13cmos5l_xnor2_1
XFILLER_60_650 VDD VSS sg13cmos5l_decap_8
X_7670_ _7670_/Q clkload3/A _7670_/D place746/X VDD VSS sg13cmos5l_dfrbpq_1
X_4882_ _4882_/Y _4882_/A _4882_/B VDD VSS sg13cmos5l_nor2_1
X_6621_ _6631_/B _6621_/A _6621_/B VDD VSS sg13cmos5l_nor2_1
X_6552_ _6861_/B _6552_/A _7689_/Q _6552_/C VDD VSS sg13cmos5l_nand3_1
X_6483_ _6485_/A _6483_/A _6483_/B VDD VSS sg13cmos5l_nand2_1
X_5503_ _5504_/B _5792_/B1 _6021_/A2 _5745_/B1 _6021_/B2 VDD VSS sg13cmos5l_a22oi_1
X_5434_ _5434_/X _5434_/A _5434_/B VDD VSS sg13cmos5l_and2_1
X_7104_ _7104_/Y _7262_/A _7276_/S _7103_/X VDD VSS sg13cmos5l_a21oi_1
X_5365_ _5416_/A _5365_/A _5365_/B VDD VSS sg13cmos5l_nand2_1
Xinput809 input809/X bank_B_wdata[14] VDD VSS sg13cmos5l_buf_1
X_5296_ _5359_/A _5227_/B _5227_/A _5295_/Y VDD VSS sg13cmos5l_a21oi_1
X_4316_ _4369_/B _4692_/A _4316_/B VDD VSS sg13cmos5l_xnor2_1
X_7035_ _7170_/A _6845_/B _7082_/B _7034_/X VDD VSS sg13cmos5l_a21oi_1
X_4247_ _7669_/D _4247_/A _4351_/A VDD VSS sg13cmos5l_nor2_1
XFILLER_87_547 VDD VSS sg13cmos5l_decap_8
XFILLER_55_400 VDD VSS sg13cmos5l_fill_1
X_4178_ _4179_/A _4178_/A _4178_/B VDD VSS sg13cmos5l_xor2_1
XFILLER_43_617 VDD VSS sg13cmos5l_fill_1
XFILLER_83_775 VDD VSS sg13cmos5l_decap_8
XFILLER_70_414 VDD VSS sg13cmos5l_decap_8
XFILLER_51_650 VDD VSS sg13cmos5l_fill_2
X_6819_ _7114_/A _7018_/B _7018_/A _6818_/Y VDD VSS sg13cmos5l_o21ai_1
XFILLER_78_569 VDD VSS sg13cmos5l_fill_2
XFILLER_76_43 VDD VSS sg13cmos5l_decap_8
XFILLER_86_591 VDD VSS sg13cmos5l_decap_8
XFILLER_76_98 VDD VSS sg13cmos5l_fill_2
XFILLER_62_915 VDD VSS sg13cmos5l_fill_2
XFILLER_92_20 VDD VSS sg13cmos5l_fill_1
XFILLER_73_285 VDD VSS sg13cmos5l_decap_8
XFILLER_41_160 VDD VSS sg13cmos5l_fill_2
Xwire972 wire972/X wire972/A VDD VSS sg13cmos5l_buf_2
Xwire983 _4003_/A wire984/X VDD VSS sg13cmos5l_buf_8
Xwire994 _5205_/A wire994/A VDD VSS sg13cmos5l_buf_2
XFILLER_69_525 VDD VSS sg13cmos5l_fill_1
X_5150_ _5197_/B _5586_/A _5150_/B VDD VSS sg13cmos5l_xnor2_1
X_4101_ _6181_/B _4108_/B _4108_/C VDD VSS sg13cmos5l_xnor2_1
XFILLER_38_912 VDD VSS sg13cmos5l_decap_4
XFILLER_49_260 VDD VSS sg13cmos5l_fill_1
X_4032_ _4042_/B _4032_/A _4032_/B VDD VSS sg13cmos5l_xor2_1
XFILLER_49_282 VDD VSS sg13cmos5l_fill_1
XFILLER_65_742 VDD VSS sg13cmos5l_decap_8
XFILLER_65_775 VDD VSS sg13cmos5l_fill_2
XFILLER_52_414 VDD VSS sg13cmos5l_fill_1
XFILLER_65_786 VDD VSS sg13cmos5l_decap_8
X_5983_ _6033_/B _6057_/A _5983_/B VDD VSS sg13cmos5l_xnor2_1
XFILLER_80_712 VDD VSS sg13cmos5l_decap_8
XFILLER_64_296 VDD VSS sg13cmos5l_decap_8
X_7722_ _7722_/Q clkload6/A _7722_/D place752/X VDD VSS sg13cmos5l_dfrbpq_1
X_4934_ _4990_/A _5442_/A _4934_/B VDD VSS sg13cmos5l_xnor2_1
XANTENNA_12 _7710_/D VDD VSS sg13cmos5l_antennanp
XANTENNA_23 input821/X VDD VSS sg13cmos5l_antennanp
X_7653_ _7654_/A _7657_/A _7653_/B VDD VSS sg13cmos5l_nand2_2
X_4865_ _4866_/B _4865_/A _4916_/A VDD VSS sg13cmos5l_xnor2_1
XANTENNA_34 input794/X VDD VSS sg13cmos5l_antennanp
X_7584_ _7588_/A _7624_/C _7584_/B _7624_/B _7624_/A VDD VSS sg13cmos5l_nor4_2
X_6604_ _6614_/A _6605_/B _6605_/A VDD VSS sg13cmos5l_nor2_2
X_4796_ _4796_/Y _4796_/A _4744_/A VDD VSS sg13cmos5l_nor2b_1
X_6535_ _6537_/A _6542_/A _6542_/B VDD VSS sg13cmos5l_xnor2_1
X_6466_ _6468_/B _6466_/A VDD VSS sg13cmos5l_inv_1
X_6397_ _6541_/B _6397_/A _6548_/B _6548_/C VDD VSS sg13cmos5l_nor3_1
X_5417_ _5419_/A _5417_/A _5355_/A VDD VSS sg13cmos5l_nor2b_1
XFILLER_88_801 VDD VSS sg13cmos5l_decap_8
X_5348_ _5349_/B _5346_/Y _5285_/B _5347_/Y VDD VSS sg13cmos5l_o21ai_1
XFILLER_88_812 VDD VSS sg13cmos5l_decap_4
XFILLER_87_300 VDD VSS sg13cmos5l_fill_1
X_7018_ _7018_/Y _7018_/A _7018_/B VDD VSS sg13cmos5l_nand2_1
X_5279_ _5328_/B _5586_/A _5279_/B VDD VSS sg13cmos5l_xnor2_1
XFILLER_87_388 VDD VSS sg13cmos5l_decap_8
XFILLER_87_355 VDD VSS sg13cmos5l_fill_1
XFILLER_56_720 VDD VSS sg13cmos5l_fill_2
XFILLER_44_904 VDD VSS sg13cmos5l_decap_8
XFILLER_56_786 VDD VSS sg13cmos5l_decap_4
XFILLER_70_200 VDD VSS sg13cmos5l_decap_4
XFILLER_71_734 VDD VSS sg13cmos5l_fill_1
XFILLER_83_572 VDD VSS sg13cmos5l_decap_8
XFILLER_79_812 VDD VSS sg13cmos5l_decap_8
Xbank_A_sram.gen_ihp_256x32.u_sram_256x32_1090 bank_A_sram.gen_ihp_256x32.u_sram_256x32_1090/L_LO
+ VDD VSS sg13cmos5l_tielo
XFILLER_78_344 VDD VSS sg13cmos5l_decap_8
XFILLER_79_889 VDD VSS sg13cmos5l_decap_8
XFILLER_16_8 VDD VSS sg13cmos5l_decap_8
XFILLER_59_591 VDD VSS sg13cmos5l_fill_1
XFILLER_46_274 VDD VSS sg13cmos5l_fill_1
XFILLER_46_296 VDD VSS sg13cmos5l_decap_8
XFILLER_61_255 VDD VSS sg13cmos5l_fill_2
XFILLER_42_480 VDD VSS sg13cmos5l_fill_1
X_4650_ _4651_/B _4524_/A _3951_/A _4762_/B1 _5017_/B2 VDD VSS sg13cmos5l_a22oi_1
X_6320_ _6791_/B _6320_/A _6320_/B VDD VSS sg13cmos5l_nand2_2
X_4581_ _4581_/Y _4581_/A _4581_/B VDD VSS sg13cmos5l_nor2_1
X_6251_ _6268_/B _6251_/A _6277_/A _7274_/A _6277_/B VDD VSS sg13cmos5l_nand4_1
X_6182_ _7665_/D _6182_/A _6182_/B VDD VSS sg13cmos5l_xnor2_1
X_5202_ _5212_/A _5757_/A _5202_/B VDD VSS sg13cmos5l_xnor2_1
XFILLER_69_322 VDD VSS sg13cmos5l_decap_8
X_5133_ _5182_/A _5192_/A _5133_/B VDD VSS sg13cmos5l_xnor2_1
XFILLER_123_18 VDD VSS sg13cmos5l_fill_2
XFILLER_38_731 VDD VSS sg13cmos5l_decap_8
X_5064_ _5065_/B _5622_/B1 _5322_/A2 _5557_/B1 _5322_/B2 VDD VSS sg13cmos5l_a22oi_1
XFILLER_84_325 VDD VSS sg13cmos5l_decap_4
XFILLER_38_753 VDD VSS sg13cmos5l_fill_2
X_4015_ _4040_/A _4015_/A _4015_/B VDD VSS sg13cmos5l_nand2_1
XFILLER_38_786 VDD VSS sg13cmos5l_decap_8
XFILLER_65_583 VDD VSS sg13cmos5l_decap_8
XFILLER_53_745 VDD VSS sg13cmos5l_decap_8
X_5966_ _6015_/B _5966_/A _5966_/B VDD VSS sg13cmos5l_xnor2_1
XFILLER_40_428 VDD VSS sg13cmos5l_fill_2
X_7705_ _7705_/Q _7728_/CLK _7705_/D place753/X VDD VSS sg13cmos5l_dfrbpq_1
X_5897_ _5897_/Y _5897_/A _5897_/B VDD VSS sg13cmos5l_nand2_1
X_4917_ _4981_/B _4866_/B _4866_/A _4916_/Y VDD VSS sg13cmos5l_a21oi_1
XFILLER_80_597 VDD VSS sg13cmos5l_decap_8
X_7636_ _7637_/A _7657_/A _7636_/B VDD VSS sg13cmos5l_nand2_2
X_4848_ _4849_/B _4846_/Y _4848_/B VDD VSS sg13cmos5l_nand2b_1
XFILLER_120_8 VDD VSS sg13cmos5l_decap_8
X_7567_ _7621_/A _7567_/A _7567_/B VDD VSS sg13cmos5l_xnor2_1
X_4779_ _4780_/B _4711_/A _4779_/B VDD VSS sg13cmos5l_nand2b_1
X_7498_ _7499_/B _7498_/A _7498_/B _7574_/B VDD VSS sg13cmos5l_nand3_1
X_6518_ _6534_/A _6518_/A _6518_/B _6518_/C VDD VSS sg13cmos5l_nor3_2
X_6449_ _6451_/A _6457_/C _6457_/A VDD VSS sg13cmos5l_xnor2_1
XFILLER_57_12 VDD VSS sg13cmos5l_fill_2
XFILLER_57_23 VDD VSS sg13cmos5l_decap_8
XFILLER_87_130 VDD VSS sg13cmos5l_fill_2
XFILLER_76_826 VDD VSS sg13cmos5l_decap_8
XFILLER_73_22 VDD VSS sg13cmos5l_fill_2
XFILLER_84_870 VDD VSS sg13cmos5l_decap_8
XFILLER_56_594 VDD VSS sg13cmos5l_decap_8
XFILLER_43_277 VDD VSS sg13cmos5l_fill_1
XFILLER_44_778 VDD VSS sg13cmos5l_decap_8
XFILLER_73_88 VDD VSS sg13cmos5l_decap_8
XFILLER_79_653 VDD VSS sg13cmos5l_decap_8
XFILLER_66_325 VDD VSS sg13cmos5l_decap_4
XFILLER_78_163 VDD VSS sg13cmos5l_fill_1
XFILLER_82_818 VDD VSS sg13cmos5l_decap_8
XFILLER_75_870 VDD VSS sg13cmos5l_decap_8
XFILLER_50_704 VDD VSS sg13cmos5l_fill_1
XFILLER_62_564 VDD VSS sg13cmos5l_fill_2
X_5820_ _5850_/B _5854_/A _5820_/B VDD VSS sg13cmos5l_xnor2_1
XFILLER_62_586 VDD VSS sg13cmos5l_decap_8
X_5751_ _5752_/B _5751_/A _5789_/A VDD VSS sg13cmos5l_xnor2_1
X_4702_ _4703_/B _4947_/A _4767_/B _4702_/C VDD VSS sg13cmos5l_nor3_1
X_7421_ _7574_/A _7421_/A VDD VSS sg13cmos5l_inv_1
X_5682_ _5693_/A _5625_/B _5547_/A _5682_/S VDD VSS sg13cmos5l_mux2_1
X_4633_ _4680_/A _4690_/A _4633_/B VDD VSS sg13cmos5l_xnor2_1
X_7352_ _7355_/B _7380_/B _7360_/A VDD VSS sg13cmos5l_xnor2_1
X_7283_ _7284_/A _7152_/Y _7233_/B _7182_/A VDD VSS sg13cmos5l_a21oi_1
X_6303_ _6602_/B _6611_/B _6465_/B VDD VSS sg13cmos5l_nand2_1
X_4495_ _4496_/A _4495_/A _4495_/B VDD VSS sg13cmos5l_nand2_1
Xhold2025 _7124_/A _7718_/Q VDD VSS sg13cmos5l_dlygate4sd3_1
X_6165_ _6175_/C _6165_/A _6173_/B VDD VSS sg13cmos5l_xnor2_1
X_6096_ _6129_/B _6096_/A _6096_/B VDD VSS sg13cmos5l_xnor2_1
XFILLER_27_15 VDD VSS sg13cmos5l_decap_4
X_5047_ _5171_/B _4993_/B _4993_/A _5046_/Y VDD VSS sg13cmos5l_a21oi_1
XFILLER_85_667 VDD VSS sg13cmos5l_decap_8
XFILLER_38_550 VDD VSS sg13cmos5l_decap_8
XFILLER_38_561 VDD VSS sg13cmos5l_fill_1
XFILLER_72_306 VDD VSS sg13cmos5l_decap_8
XFILLER_84_177 VDD VSS sg13cmos5l_decap_4
XFILLER_81_840 VDD VSS sg13cmos5l_decap_8
XFILLER_43_14 VDD VSS sg13cmos5l_fill_2
X_6998_ _7154_/A _6728_/A _7046_/B _6997_/Y VDD VSS sg13cmos5l_a21oi_1
XFILLER_53_586 VDD VSS sg13cmos5l_decap_8
X_5949_ _5984_/S _5985_/B1 _6082_/A2 _5949_/B1 _6082_/B2 VDD VSS sg13cmos5l_a22oi_1
X_7619_ _7620_/D _7619_/A _7619_/B _7619_/C _7619_/D VDD VSS sg13cmos5l_and4_1
XFILLER_4_19 VDD VSS sg13cmos5l_fill_2
XFILLER_49_815 VDD VSS sg13cmos5l_decap_8
XFILLER_76_667 VDD VSS sg13cmos5l_decap_8
XFILLER_57_881 VDD VSS sg13cmos5l_decap_8
XFILLER_75_188 VDD VSS sg13cmos5l_decap_8
XFILLER_84_65 VDD VSS sg13cmos5l_fill_2
XFILLER_72_851 VDD VSS sg13cmos5l_decap_8
XFILLER_75_199 VDD VSS sg13cmos5l_fill_1
XFILLER_44_553 VDD VSS sg13cmos5l_fill_1
XFILLER_40_781 VDD VSS sg13cmos5l_decap_8
X_4280_ _4319_/B _4532_/A _4280_/B VDD VSS sg13cmos5l_xnor2_1
XFILLER_67_612 VDD VSS sg13cmos5l_decap_8
Xbank_B_sram.gen_ihp_256x32.u_sram_256x32_1109 bank_B_sram.gen_ihp_256x32.u_sram_256x32_1109/L_LO
+ VDD VSS sg13cmos5l_tielo
XFILLER_48_870 VDD VSS sg13cmos5l_decap_8
XFILLER_67_678 VDD VSS sg13cmos5l_decap_4
XFILLER_82_615 VDD VSS sg13cmos5l_decap_8
XFILLER_63_840 VDD VSS sg13cmos5l_decap_8
X_6921_ _6922_/A _6921_/A VDD VSS sg13cmos5l_inv_1
XFILLER_81_125 VDD VSS sg13cmos5l_decap_8
XFILLER_120_19 VDD VSS sg13cmos5l_fill_2
XFILLER_62_350 VDD VSS sg13cmos5l_decap_4
X_6852_ _6853_/A _6852_/A1 _6820_/B _6436_/B VDD VSS sg13cmos5l_a21oi_1
XFILLER_62_361 VDD VSS sg13cmos5l_fill_1
X_5803_ _5804_/B _6084_/B1 _4045_/Y _6082_/A1 _4074_/Y VDD VSS sg13cmos5l_a22oi_1
X_3995_ _5810_/A _3995_/A _3995_/B VDD VSS sg13cmos5l_nand2_1
X_5734_ _5735_/B _5734_/A _5736_/B VDD VSS sg13cmos5l_nand2_1
X_5665_ _5667_/C _5665_/A _5665_/B VDD VSS sg13cmos5l_nand2_1
X_4616_ _4616_/X _4616_/A _4616_/B VDD VSS sg13cmos5l_and2_1
X_7335_ _7524_/B _7335_/A _7360_/B VDD VSS sg13cmos5l_nand2_1
X_5596_ _5597_/B _5528_/A _5596_/B VDD VSS sg13cmos5l_nand2b_1
X_4547_ _4547_/Y _4547_/A _4547_/B _4547_/C VDD VSS sg13cmos5l_nand3_1
Xrebuffer1420 rebuffer1420/X _6564_/A VDD VSS sg13cmos5l_buf_1
X_7266_ _7266_/Y _7298_/A1 _7103_/A _7265_/Y VDD VSS sg13cmos5l_o21ai_1
X_4478_ _7673_/D _4478_/A _4478_/B VDD VSS sg13cmos5l_xnor2_1
Xfanout934 _5117_/B1 _4755_/B1 VDD VSS sg13cmos5l_buf_1
Xrebuffer1453 rebuffer1453/X _6555_/A VDD VSS sg13cmos5l_buf_1
Xrebuffer1442 rebuffer1442/X rebuffer1443/X VDD VSS sg13cmos5l_buf_1
Xrebuffer1431 rebuffer1431/X _7381_/A VDD VSS sg13cmos5l_buf_1
X_7197_ _7197_/Y _7186_/Y _7190_/Y _7297_/A _7196_/Y VDD VSS sg13cmos5l_a22oi_1
X_6217_ _6217_/Y _6223_/A _6217_/B VDD VSS sg13cmos5l_nand2_1
XFILLER_57_100 VDD VSS sg13cmos5l_decap_4
Xfanout945 _5792_/B1 _5385_/A1 VDD VSS sg13cmos5l_buf_1
Xfanout956 _4620_/B1 _4738_/B1 VDD VSS sg13cmos5l_buf_1
X_6148_ _6150_/A _6149_/B _6149_/A VDD VSS sg13cmos5l_nor2_1
XFILLER_38_58 VDD VSS sg13cmos5l_decap_8
XFILLER_38_69 VDD VSS sg13cmos5l_fill_2
XFILLER_57_144 VDD VSS sg13cmos5l_decap_8
XFILLER_57_155 VDD VSS sg13cmos5l_fill_2
XFILLER_72_103 VDD VSS sg13cmos5l_fill_2
X_6079_ _6079_/Y _6079_/A _6063_/A VDD VSS sg13cmos5l_nor2b_1
XFILLER_85_486 VDD VSS sg13cmos5l_fill_1
XFILLER_85_475 VDD VSS sg13cmos5l_decap_8
XFILLER_54_24 VDD VSS sg13cmos5l_decap_8
XFILLER_54_57 VDD VSS sg13cmos5l_fill_1
XFILLER_54_873 VDD VSS sg13cmos5l_decap_8
XFILLER_41_534 VDD VSS sg13cmos5l_fill_2
XFILLER_41_556 VDD VSS sg13cmos5l_decap_8
XFILLER_41_567 VDD VSS sg13cmos5l_fill_1
XFILLER_79_32 VDD VSS sg13cmos5l_fill_2
XFILLER_76_420 VDD VSS sg13cmos5l_fill_1
XFILLER_63_103 VDD VSS sg13cmos5l_fill_1
XFILLER_63_136 VDD VSS sg13cmos5l_decap_8
XFILLER_45_862 VDD VSS sg13cmos5l_decap_8
XFILLER_63_158 VDD VSS sg13cmos5l_decap_8
XFILLER_60_832 VDD VSS sg13cmos5l_decap_8
XFILLER_74_4 VDD VSS sg13cmos5l_fill_1
X_5450_ _5497_/B _5702_/A _5450_/B VDD VSS sg13cmos5l_xnor2_1
X_4401_ _4461_/A _4334_/A _4399_/Y _4400_/Y VDD VSS sg13cmos5l_o21ai_1
X_5381_ _5388_/A _5381_/A _5381_/B VDD VSS sg13cmos5l_xnor2_1
X_7120_ _7150_/A _7289_/A _7104_/Y _7119_/Y VDD VSS sg13cmos5l_o21ai_1
X_4332_ _4333_/B _4382_/A _4382_/B VDD VSS sg13cmos5l_xor2_1
Xfanout208 place754/A rst_n VDD VSS sg13cmos5l_buf_1
X_4263_ _4264_/B wire982/X _4048_/A _4620_/B1 _4311_/B2 VDD VSS sg13cmos5l_a22oi_1
X_6002_ _6073_/A _6004_/B _6004_/A VDD VSS sg13cmos5l_nor2_1
X_4194_ _4251_/B _4194_/A _4194_/B VDD VSS sg13cmos5l_nand2_1
XFILLER_55_604 VDD VSS sg13cmos5l_decap_4
XFILLER_54_114 VDD VSS sg13cmos5l_decap_8
X_6904_ _6904_/Y _6916_/B _6904_/B VDD VSS sg13cmos5l_nor2_1
XFILLER_51_832 VDD VSS sg13cmos5l_decap_8
XFILLER_24_16 VDD VSS sg13cmos5l_decap_4
XFILLER_62_191 VDD VSS sg13cmos5l_decap_8
Xplace670 _7360_/B _7720_/Q VDD VSS sg13cmos5l_buf_1
Xplace681 _7277_/B _6891_/B VDD VSS sg13cmos5l_buf_1
Xplace692 _7164_/A _7184_/B VDD VSS sg13cmos5l_buf_1
X_6835_ _6941_/A _6835_/A _6835_/B VDD VSS sg13cmos5l_xnor2_1
X_6766_ _6766_/X _6766_/A _6927_/B VDD VSS sg13cmos5l_and2_1
X_3978_ _3978_/Y _5706_/B _5645_/A VDD VSS sg13cmos5l_nand2_1
X_5717_ _5769_/A _5710_/B _5646_/B _5716_/Y VDD VSS sg13cmos5l_a21oi_1
X_5648_ _5649_/B _5694_/A _5694_/B VDD VSS sg13cmos5l_xor2_1
X_5579_ _5579_/X _5579_/A _5579_/B VDD VSS sg13cmos5l_and2_1
X_7318_ _7318_/Y _7318_/A _7318_/B VDD VSS sg13cmos5l_nand2_1
X_7249_ _7250_/B _7296_/A _7249_/B VDD VSS sg13cmos5l_nor2_1
Xrebuffer1250 _7658_/B _7632_/Y VDD VSS sg13cmos5l_buf_8
Xrebuffer1261 _6332_/A _6255_/B VDD VSS sg13cmos5l_buf_1
XFILLER_78_729 VDD VSS sg13cmos5l_fill_2
XFILLER_58_420 VDD VSS sg13cmos5l_decap_4
Xrebuffer1272 rebuffer1272/X rebuffer1273/X VDD VSS sg13cmos5l_buf_1
Xrebuffer1283 rebuffer1283/X rebuffer1284/X VDD VSS sg13cmos5l_buf_1
Xrebuffer1294 rebuffer1294/X rebuffer1295/X VDD VSS sg13cmos5l_buf_1
XFILLER_46_626 VDD VSS sg13cmos5l_decap_8
XFILLER_74_913 VDD VSS sg13cmos5l_decap_4
XFILLER_86_773 VDD VSS sg13cmos5l_decap_8
XFILLER_45_136 VDD VSS sg13cmos5l_fill_2
XFILLER_61_607 VDD VSS sg13cmos5l_decap_8
XFILLER_61_618 VDD VSS sg13cmos5l_decap_8
XFILLER_65_78 VDD VSS sg13cmos5l_fill_2
XFILLER_54_692 VDD VSS sg13cmos5l_fill_2
XFILLER_42_865 VDD VSS sg13cmos5l_decap_8
Xmax_cap1015 _4275_/A _4583_/B1 VDD VSS sg13cmos5l_buf_2
XFILLER_49_442 VDD VSS sg13cmos5l_decap_8
XFILLER_65_913 VDD VSS sg13cmos5l_decap_4
XFILLER_37_637 VDD VSS sg13cmos5l_decap_8
XFILLER_37_648 VDD VSS sg13cmos5l_decap_4
XFILLER_77_795 VDD VSS sg13cmos5l_decap_8
XFILLER_64_489 VDD VSS sg13cmos5l_fill_1
X_4950_ _4951_/B _4825_/A _3951_/A _4766_/A _5017_/B2 VDD VSS sg13cmos5l_a22oi_1
X_4881_ _4897_/A _4881_/A _4881_/B VDD VSS sg13cmos5l_xor2_1
X_6620_ _6753_/B _6620_/A _6620_/B VDD VSS sg13cmos5l_nand2_2
X_6551_ _6553_/A _6552_/A _6552_/C _7689_/Q VDD VSS sg13cmos5l_a21oi_1
X_5502_ _5528_/A _5468_/B _5468_/A _5501_/Y VDD VSS sg13cmos5l_a21oi_1
XFILLER_65_0 VDD VSS sg13cmos5l_fill_1
X_6482_ _6488_/A _6482_/A _6482_/B VDD VSS sg13cmos5l_nand2_2
X_5433_ _5436_/A _5492_/S _5433_/B VDD VSS sg13cmos5l_xnor2_1
X_5364_ _5365_/B _5364_/A _5364_/B VDD VSS sg13cmos5l_nand2_1
X_7103_ _7103_/X _7103_/A _7195_/B VDD VSS sg13cmos5l_and2_1
X_4315_ _4316_/B _4620_/B1 _4378_/A2 _4565_/B1 _4378_/B2 VDD VSS sg13cmos5l_a22oi_1
X_5295_ _5295_/Y _5295_/A _5295_/B VDD VSS sg13cmos5l_nor2_1
XFILLER_87_537 VDD VSS sg13cmos5l_fill_2
X_7034_ _7034_/X _7034_/A _7078_/B VDD VSS sg13cmos5l_and2_1
X_4246_ _4351_/A _4294_/B VDD VSS sg13cmos5l_inv_1
X_4177_ _4178_/B _4212_/A _4212_/B VDD VSS sg13cmos5l_xor2_1
XFILLER_67_283 VDD VSS sg13cmos5l_decap_8
XFILLER_83_754 VDD VSS sg13cmos5l_decap_8
XFILLER_82_242 VDD VSS sg13cmos5l_decap_4
XFILLER_55_489 VDD VSS sg13cmos5l_decap_8
XFILLER_70_459 VDD VSS sg13cmos5l_decap_8
XFILLER_51_662 VDD VSS sg13cmos5l_fill_1
X_6818_ _6818_/Y _7014_/B _7087_/A VDD VSS sg13cmos5l_nand2_1
XFILLER_51_69 VDD VSS sg13cmos5l_fill_1
X_6749_ _6751_/A _7004_/A _6739_/Y _6748_/Y VDD VSS sg13cmos5l_o21ai_1
Xoutput890 bank_A_rdata[29] wire991/A VDD VSS sg13cmos5l_buf_1
XFILLER_76_22 VDD VSS sg13cmos5l_decap_8
XFILLER_59_751 VDD VSS sg13cmos5l_decap_4
XFILLER_86_570 VDD VSS sg13cmos5l_decap_8
XFILLER_76_77 VDD VSS sg13cmos5l_decap_8
XFILLER_61_415 VDD VSS sg13cmos5l_fill_2
XFILLER_74_787 VDD VSS sg13cmos5l_decap_8
XFILLER_42_640 VDD VSS sg13cmos5l_decap_4
XFILLER_61_437 VDD VSS sg13cmos5l_fill_1
XFILLER_42_684 VDD VSS sg13cmos5l_decap_8
Xwire962 wire962/X wire962/A VDD VSS sg13cmos5l_buf_2
Xwire973 wire973/X wire973/A VDD VSS sg13cmos5l_buf_2
Xwire984 wire984/X wire984/A VDD VSS sg13cmos5l_buf_4
Xwire995 _5145_/A wire995/A VDD VSS sg13cmos5l_buf_2
X_4100_ _6182_/A _4100_/A _4100_/B VDD VSS sg13cmos5l_nor2_1
X_4031_ _4032_/B _4050_/A _4050_/B VDD VSS sg13cmos5l_xor2_1
XFILLER_37_412 VDD VSS sg13cmos5l_fill_1
XFILLER_77_581 VDD VSS sg13cmos5l_fill_1
XFILLER_53_916 VDD VSS sg13cmos5l_fill_2
XFILLER_64_275 VDD VSS sg13cmos5l_decap_8
X_5982_ _5983_/B _5982_/A _5982_/B VDD VSS sg13cmos5l_xnor2_1
X_7721_ _7721_/Q _7728_/CLK _7721_/D place752/X VDD VSS sg13cmos5l_dfrbpq_1
X_4933_ _4934_/B _5493_/B1 _5322_/A2 _5430_/B1 _5322_/B2 VDD VSS sg13cmos5l_a22oi_1
XFILLER_80_746 VDD VSS sg13cmos5l_fill_2
XANTENNA_13 _7705_/D VDD VSS sg13cmos5l_antennanp
X_7652_ _7653_/B _7652_/A _7652_/B VDD VSS sg13cmos5l_xnor2_1
X_4864_ _4916_/A _4817_/B _4817_/A _4863_/X VDD VSS sg13cmos5l_a21oi_1
XANTENNA_24 input827/X VDD VSS sg13cmos5l_antennanp
XANTENNA_35 input792/X VDD VSS sg13cmos5l_antennanp
X_7583_ _7624_/A _7583_/A _7583_/B VDD VSS sg13cmos5l_xnor2_1
X_6603_ _6605_/A _6603_/A _6603_/B VDD VSS sg13cmos5l_nand2_1
X_4795_ _4852_/A _4781_/B _4781_/A _4794_/Y VDD VSS sg13cmos5l_a21o_1
X_6534_ _6542_/B _6534_/A _6534_/B VDD VSS sg13cmos5l_nand2_2
X_6465_ _6466_/A _6483_/A _6465_/B VDD VSS sg13cmos5l_nand2_1
X_5416_ _5420_/A _5416_/A _5481_/A VDD VSS sg13cmos5l_xnor2_1
X_6396_ _6827_/B _6396_/A _6396_/B VDD VSS sg13cmos5l_nand2_2
X_5347_ _5347_/Y _5284_/A _5347_/B VDD VSS sg13cmos5l_nand2b_1
XFILLER_88_835 VDD VSS sg13cmos5l_decap_4
X_5278_ _5279_/B _5145_/A _5585_/A2 _5076_/A _5585_/B2 VDD VSS sg13cmos5l_a22oi_1
X_7017_ _7237_/B _7013_/Y _7168_/B _7016_/Y VDD VSS sg13cmos5l_a21oi_1
X_4229_ _4232_/B _4229_/A _4252_/A VDD VSS sg13cmos5l_xnor2_1
XFILLER_87_367 VDD VSS sg13cmos5l_decap_8
XFILLER_56_754 VDD VSS sg13cmos5l_decap_8
XFILLER_102_20 VDD VSS sg13cmos5l_fill_1
XFILLER_55_264 VDD VSS sg13cmos5l_fill_2
XFILLER_70_223 VDD VSS sg13cmos5l_fill_1
XFILLER_71_746 VDD VSS sg13cmos5l_decap_4
XFILLER_70_256 VDD VSS sg13cmos5l_fill_1
XFILLER_7_19 VDD VSS sg13cmos5l_fill_2
Xbank_A_sram.gen_ihp_256x32.u_sram_256x32_1080 bank_A_sram.gen_ihp_256x32.u_sram_256x32_1080/L_LO
+ VDD VSS sg13cmos5l_tielo
Xbank_A_sram.gen_ihp_256x32.u_sram_256x32_1091 bank_A_sram.gen_ihp_256x32.u_sram_256x32_1091/L_LO
+ VDD VSS sg13cmos5l_tielo
XFILLER_79_868 VDD VSS sg13cmos5l_decap_8
XFILLER_47_765 VDD VSS sg13cmos5l_fill_2
XFILLER_47_798 VDD VSS sg13cmos5l_fill_2
XFILLER_62_779 VDD VSS sg13cmos5l_decap_4
X_4580_ _4597_/A _4580_/A _4580_/B VDD VSS sg13cmos5l_xor2_1
X_6250_ _6251_/A _6250_/A _6499_/C _7709_/Q VDD VSS sg13cmos5l_nor3_2
X_6181_ _6182_/B _6181_/A _6181_/B VDD VSS sg13cmos5l_xnor2_1
X_5201_ _5202_/B _4946_/A _5514_/A2 _4888_/A _5756_/B2 VDD VSS sg13cmos5l_a22oi_1
XFILLER_69_312 VDD VSS sg13cmos5l_fill_2
X_5132_ _5133_/B _5684_/B1 _5322_/A2 _5622_/B1 _5322_/B2 VDD VSS sg13cmos5l_a22oi_1
XFILLER_69_367 VDD VSS sg13cmos5l_decap_8
XFILLER_85_849 VDD VSS sg13cmos5l_decap_8
XFILLER_38_765 VDD VSS sg13cmos5l_decap_8
X_4014_ _4100_/A _4015_/A _4014_/B VDD VSS sg13cmos5l_nand2_1
XFILLER_84_348 VDD VSS sg13cmos5l_decap_4
XFILLER_53_724 VDD VSS sg13cmos5l_fill_1
XFILLER_41_908 VDD VSS sg13cmos5l_decap_8
X_5965_ _5966_/B _6010_/B _6010_/A VDD VSS sg13cmos5l_xor2_1
X_7704_ _7704_/Q _7704_/CLK _7704_/D place753/X VDD VSS sg13cmos5l_dfrbpq_1
X_5896_ _5906_/A _5982_/A _5896_/B VDD VSS sg13cmos5l_xnor2_1
X_4916_ _4916_/Y _4916_/A _4865_/A VDD VSS sg13cmos5l_nor2b_1
X_7635_ _7636_/B _7635_/A _7635_/B VDD VSS sg13cmos5l_xor2_1
X_4847_ _4848_/B _4847_/A _4847_/B VDD VSS sg13cmos5l_nand2_2
X_7566_ _7569_/C _7621_/B _7566_/B VDD VSS sg13cmos5l_nand2_1
X_4778_ _4780_/A _4712_/B _4778_/B VDD VSS sg13cmos5l_nand2b_1
X_7497_ _7497_/Y _7498_/A _7574_/B _7498_/B VDD VSS sg13cmos5l_a21oi_1
X_6517_ _6518_/A _6927_/B _7144_/B _6517_/C _6548_/D VDD VSS sg13cmos5l_nor4_1
X_6448_ _6457_/C _6483_/A _6448_/B VDD VSS sg13cmos5l_nand2_1
X_6379_ _6389_/A _6379_/A _6380_/A VDD VSS sg13cmos5l_nor2b_2
XFILLER_79_109 VDD VSS sg13cmos5l_fill_2
XFILLER_87_142 VDD VSS sg13cmos5l_fill_2
XFILLER_76_805 VDD VSS sg13cmos5l_decap_8
XFILLER_57_46 VDD VSS sg13cmos5l_fill_1
XFILLER_88_698 VDD VSS sg13cmos5l_fill_2
XFILLER_87_164 VDD VSS sg13cmos5l_decap_8
XFILLER_87_197 VDD VSS sg13cmos5l_decap_4
XFILLER_71_510 VDD VSS sg13cmos5l_decap_4
XFILLER_71_543 VDD VSS sg13cmos5l_decap_8
XFILLER_73_56 VDD VSS sg13cmos5l_fill_2
Xclkbuf_0_clk_i_regs clkbuf_0_clk_i_regs/X clkbuf_regs_0_clk_i/X VDD VSS sg13cmos5l_buf_16
XFILLER_98_20 VDD VSS sg13cmos5l_fill_1
XFILLER_78_120 VDD VSS sg13cmos5l_decap_4
XFILLER_78_131 VDD VSS sg13cmos5l_decap_4
XFILLER_47_551 VDD VSS sg13cmos5l_fill_1
XFILLER_62_598 VDD VSS sg13cmos5l_fill_2
X_5750_ _5789_/A _5704_/B _5704_/A _5749_/X VDD VSS sg13cmos5l_a21oi_1
X_5681_ _5775_/A _5629_/B _5629_/A _5680_/Y VDD VSS sg13cmos5l_a21oi_1
X_4701_ _4702_/C _4701_/A VDD VSS sg13cmos5l_inv_1
X_7420_ _7421_/A _7431_/B _7431_/A VDD VSS sg13cmos5l_nor2_1
X_4632_ _4633_/B _5178_/B1 _4753_/A2 _5117_/B1 _4753_/B2 VDD VSS sg13cmos5l_a22oi_1
XFILLER_118_19 VDD VSS sg13cmos5l_fill_2
X_7351_ _7360_/A _7369_/A _7167_/Y _7350_/Y VDD VSS sg13cmos5l_o21ai_1
X_7282_ _7556_/A _7557_/A _7306_/A VDD VSS sg13cmos5l_xnor2_1
X_6302_ _6465_/B _6979_/B _6499_/C _6533_/C VDD VSS sg13cmos5l_nor3_1
X_4494_ _4495_/B _4494_/A _4494_/B VDD VSS sg13cmos5l_xor2_1
XFILLER_69_120 VDD VSS sg13cmos5l_fill_2
X_6164_ _6173_/B _6143_/B _6143_/A _6163_/Y VDD VSS sg13cmos5l_a21o_1
XFILLER_57_315 VDD VSS sg13cmos5l_fill_1
XFILLER_69_164 VDD VSS sg13cmos5l_fill_2
X_6095_ _6096_/B _6095_/A _6095_/B VDD VSS sg13cmos5l_nand2_1
X_5115_ _5126_/A _5053_/B _4967_/A _5115_/S VDD VSS sg13cmos5l_mux2_1
XFILLER_57_348 VDD VSS sg13cmos5l_fill_2
X_5046_ _5046_/Y _5046_/A _4992_/A VDD VSS sg13cmos5l_nor2b_1
XFILLER_85_646 VDD VSS sg13cmos5l_decap_8
XFILLER_65_370 VDD VSS sg13cmos5l_decap_4
XFILLER_65_381 VDD VSS sg13cmos5l_decap_8
X_6997_ _6997_/Y _7004_/A _6997_/B VDD VSS sg13cmos5l_nor2_1
XFILLER_41_738 VDD VSS sg13cmos5l_decap_4
XFILLER_53_598 VDD VSS sg13cmos5l_decap_8
X_5948_ _5955_/A _5912_/B _5788_/A _5948_/S VDD VSS sg13cmos5l_mux2_1
XFILLER_81_896 VDD VSS sg13cmos5l_decap_8
XFILLER_40_237 VDD VSS sg13cmos5l_fill_2
X_5879_ _5923_/A _5918_/A _5918_/B VDD VSS sg13cmos5l_xor2_1
X_7618_ _7619_/D _7618_/A _7618_/B _7618_/C _7618_/D VDD VSS sg13cmos5l_nor4_1
X_7549_ _7561_/B _7618_/B VDD VSS sg13cmos5l_inv_1
XFILLER_68_78 VDD VSS sg13cmos5l_decap_4
XFILLER_48_315 VDD VSS sg13cmos5l_fill_2
XFILLER_76_624 VDD VSS sg13cmos5l_decap_8
XFILLER_48_337 VDD VSS sg13cmos5l_fill_1
XFILLER_76_646 VDD VSS sg13cmos5l_decap_8
XFILLER_57_860 VDD VSS sg13cmos5l_decap_8
XFILLER_75_167 VDD VSS sg13cmos5l_fill_2
XFILLER_56_370 VDD VSS sg13cmos5l_fill_1
XFILLER_56_392 VDD VSS sg13cmos5l_fill_2
XFILLER_72_830 VDD VSS sg13cmos5l_decap_8
XFILLER_44_587 VDD VSS sg13cmos5l_fill_2
XFILLER_66_101 VDD VSS sg13cmos5l_fill_1
XFILLER_39_359 VDD VSS sg13cmos5l_fill_1
XFILLER_67_646 VDD VSS sg13cmos5l_fill_2
Xinput790 input790/X bank_A_wdata[5] VDD VSS sg13cmos5l_buf_1
X_6920_ _6921_/A _6917_/Y _7054_/A _7004_/A VDD VSS sg13cmos5l_mux2_1
XFILLER_62_340 VDD VSS sg13cmos5l_decap_4
X_6851_ _6947_/A _6851_/A _6851_/B VDD VSS sg13cmos5l_xor2_1
XFILLER_81_159 VDD VSS sg13cmos5l_fill_1
XFILLER_63_896 VDD VSS sg13cmos5l_decap_8
X_5802_ _5808_/A _5982_/A _5802_/B VDD VSS sg13cmos5l_xnor2_1
XFILLER_50_535 VDD VSS sg13cmos5l_fill_2
XFILLER_50_568 VDD VSS sg13cmos5l_fill_2
X_6782_ _7059_/A _7483_/B _7141_/A _7274_/A VDD VSS sg13cmos5l_a21oi_2
X_3994_ _5811_/B _3995_/A _3995_/B VDD VSS sg13cmos5l_nor2_1
XFILLER_95_0 VDD VSS sg13cmos5l_fill_1
X_5733_ _5736_/B _5733_/A _5733_/B VDD VSS sg13cmos5l_nand2_1
X_5664_ _5667_/A _5782_/A VDD VSS sg13cmos5l_inv_1
X_7403_ _7408_/B _7413_/B VDD VSS sg13cmos5l_inv_1
X_5595_ _5597_/A _5529_/B _5595_/B VDD VSS sg13cmos5l_nand2b_1
X_4615_ _4665_/A _5045_/A _4615_/B VDD VSS sg13cmos5l_nor2_1
X_7334_ _7335_/A _7369_/A _7077_/Y _7333_/Y VDD VSS sg13cmos5l_o21ai_1
X_4546_ _4548_/A _4547_/A _4547_/B _4547_/C VDD VSS sg13cmos5l_a21oi_1
Xrebuffer1410 rebuffer1410/X rebuffer1411/X VDD VSS sg13cmos5l_buf_1
X_7265_ _7265_/Y _7297_/A _7265_/B VDD VSS sg13cmos5l_nor2_1
X_4477_ _4478_/B _4479_/A _4479_/B VDD VSS sg13cmos5l_nand2_1
Xrebuffer1443 rebuffer1443/X rebuffer1444/X VDD VSS sg13cmos5l_buf_1
Xrebuffer1432 rebuffer1432/X rebuffer1433/X VDD VSS sg13cmos5l_buf_1
Xrebuffer1421 _6300_/A_N _6298_/B VDD VSS sg13cmos5l_buf_1
X_7196_ _7196_/Y _7192_/Y _7277_/B _7195_/X VDD VSS sg13cmos5l_a21oi_1
X_6216_ _6216_/Y _6223_/A _6189_/Y _6215_/Y VDD VSS sg13cmos5l_o21ai_1
XFILLER_58_602 VDD VSS sg13cmos5l_decap_8
Xfanout935 _5178_/B1 _4814_/B1 VDD VSS sg13cmos5l_buf_1
Xfanout946 _5859_/B1 _5508_/B1 VDD VSS sg13cmos5l_buf_1
Xfanout957 _4738_/A1 _4799_/B1 VDD VSS sg13cmos5l_buf_1
Xrebuffer1454 _7496_/B _7444_/A VDD VSS sg13cmos5l_buf_1
X_6147_ _6149_/A _6147_/A _6166_/A VDD VSS sg13cmos5l_xor2_1
XFILLER_57_123 VDD VSS sg13cmos5l_decap_4
XFILLER_73_605 VDD VSS sg13cmos5l_fill_2
X_6078_ _7701_/D _6078_/A _6078_/B VDD VSS sg13cmos5l_xor2_1
XFILLER_72_115 VDD VSS sg13cmos5l_decap_8
XFILLER_73_649 VDD VSS sg13cmos5l_fill_1
X_5029_ _5042_/B _5029_/A _5029_/B VDD VSS sg13cmos5l_xor2_1
XFILLER_53_340 VDD VSS sg13cmos5l_fill_1
XFILLER_54_852 VDD VSS sg13cmos5l_decap_8
XFILLER_72_148 VDD VSS sg13cmos5l_fill_1
XFILLER_81_693 VDD VSS sg13cmos5l_decap_8
XFILLER_80_170 VDD VSS sg13cmos5l_fill_2
XFILLER_70_24 VDD VSS sg13cmos5l_fill_2
XFILLER_79_44 VDD VSS sg13cmos5l_fill_1
XFILLER_77_900 VDD VSS sg13cmos5l_decap_8
XFILLER_48_123 VDD VSS sg13cmos5l_fill_2
XFILLER_88_281 VDD VSS sg13cmos5l_decap_4
XFILLER_76_432 VDD VSS sg13cmos5l_decap_4
XFILLER_48_167 VDD VSS sg13cmos5l_fill_1
XFILLER_49_668 VDD VSS sg13cmos5l_fill_2
XFILLER_76_476 VDD VSS sg13cmos5l_fill_2
XFILLER_63_115 VDD VSS sg13cmos5l_decap_8
XFILLER_64_638 VDD VSS sg13cmos5l_decap_4
XFILLER_45_841 VDD VSS sg13cmos5l_decap_8
XFILLER_44_351 VDD VSS sg13cmos5l_fill_2
XFILLER_44_384 VDD VSS sg13cmos5l_fill_2
XFILLER_44_91 VDD VSS sg13cmos5l_fill_1
XFILLER_60_888 VDD VSS sg13cmos5l_decap_8
X_4400_ _4400_/Y _4400_/A _4400_/B VDD VSS sg13cmos5l_nand2_1
X_5380_ _5381_/B _5684_/B1 _5380_/A2 _5622_/B1 _6021_/B2 VDD VSS sg13cmos5l_a22oi_1
X_4331_ _4382_/B _4532_/A _4331_/B VDD VSS sg13cmos5l_xnor2_1
X_7050_ _7050_/Y _7178_/S _7047_/Y _7126_/B VDD VSS sg13cmos5l_o21ai_1
X_6001_ _6004_/A _6001_/A VDD VSS sg13cmos5l_inv_1
XFILLER_67_432 VDD VSS sg13cmos5l_decap_8
XFILLER_67_443 VDD VSS sg13cmos5l_fill_1
X_4193_ _4508_/A _4257_/B VDD VSS sg13cmos5l_buf_1
XFILLER_39_189 VDD VSS sg13cmos5l_fill_1
XFILLER_48_690 VDD VSS sg13cmos5l_fill_2
X_6903_ _6903_/Y _6903_/A VDD VSS sg13cmos5l_inv_1
XFILLER_63_660 VDD VSS sg13cmos5l_decap_8
XFILLER_62_170 VDD VSS sg13cmos5l_decap_8
XFILLER_63_693 VDD VSS sg13cmos5l_fill_1
Xplace660 _4873_/B1 _4762_/B1 VDD VSS sg13cmos5l_buf_1
Xplace671 _7307_/B _7720_/Q VDD VSS sg13cmos5l_buf_1
Xplace682 _6891_/B _6981_/A VDD VSS sg13cmos5l_buf_1
X_6834_ _6834_/Y _6834_/A _6834_/B VDD VSS sg13cmos5l_nor2_1
XFILLER_51_888 VDD VSS sg13cmos5l_decap_8
Xplace693 _7184_/B _6951_/A VDD VSS sg13cmos5l_buf_1
X_6765_ _6766_/A _6765_/A _6765_/B VDD VSS sg13cmos5l_xnor2_1
X_3977_ _3993_/B _3977_/A _3977_/B _3977_/C VDD VSS sg13cmos5l_nor3_1
X_5716_ _5716_/Y _5716_/A _5647_/A VDD VSS sg13cmos5l_nor2b_1
X_6696_ _6696_/Y _6696_/A VDD VSS sg13cmos5l_inv_1
X_5647_ _5694_/B _5647_/A _5716_/A VDD VSS sg13cmos5l_xor2_1
X_5578_ _5592_/A _5578_/A _5578_/B VDD VSS sg13cmos5l_xor2_1
X_7317_ _7325_/A _7317_/A _7529_/A VDD VSS sg13cmos5l_nand2_2
XFILLER_49_47 VDD VSS sg13cmos5l_fill_2
Xrebuffer1251 _7635_/A rebuffer1344/X VDD VSS sg13cmos5l_buf_1
Xrebuffer1262 _6258_/A _6268_/B VDD VSS sg13cmos5l_buf_2
XFILLER_105_20 VDD VSS sg13cmos5l_fill_1
XFILLER_58_410 VDD VSS sg13cmos5l_decap_4
XFILLER_58_432 VDD VSS sg13cmos5l_fill_1
Xrebuffer1273 rebuffer1273/X rebuffer1274/X VDD VSS sg13cmos5l_buf_1
Xrebuffer1284 rebuffer1284/X rebuffer1285/X VDD VSS sg13cmos5l_buf_1
Xrebuffer1295 rebuffer1295/X rebuffer1296/X VDD VSS sg13cmos5l_buf_1
XFILLER_86_752 VDD VSS sg13cmos5l_decap_8
XFILLER_46_605 VDD VSS sg13cmos5l_fill_2
XFILLER_58_476 VDD VSS sg13cmos5l_decap_8
XFILLER_73_402 VDD VSS sg13cmos5l_fill_2
XFILLER_65_46 VDD VSS sg13cmos5l_decap_4
XFILLER_45_159 VDD VSS sg13cmos5l_decap_8
XFILLER_41_321 VDD VSS sg13cmos5l_fill_1
XFILLER_42_844 VDD VSS sg13cmos5l_decap_8
XFILLER_81_45 VDD VSS sg13cmos5l_fill_2
XFILLER_81_89 VDD VSS sg13cmos5l_fill_1
XFILLER_37_605 VDD VSS sg13cmos5l_fill_1
XFILLER_77_774 VDD VSS sg13cmos5l_decap_8
XFILLER_77_752 VDD VSS sg13cmos5l_fill_1
XFILLER_80_917 VDD VSS sg13cmos5l_fill_1
XFILLER_80_906 VDD VSS sg13cmos5l_decap_8
X_4880_ _4881_/B _4924_/A _4924_/B VDD VSS sg13cmos5l_xor2_1
X_6550_ _6552_/A _6560_/A _6560_/B VDD VSS sg13cmos5l_xnor2_1
X_5501_ _5501_/Y _5501_/A _5467_/B VDD VSS sg13cmos5l_nor2b_1
X_6481_ _6482_/B _6479_/B _7680_/Q VDD VSS sg13cmos5l_nand2b_1
XFILLER_10_19 VDD VSS sg13cmos5l_fill_2
X_5432_ _5433_/B _5432_/A _5432_/B VDD VSS sg13cmos5l_xnor2_1
XFILLER_58_0 VDD VSS sg13cmos5l_fill_2
X_5363_ _5365_/A _5363_/A _5363_/B VDD VSS sg13cmos5l_nand2_1
X_7102_ _7103_/A _7134_/B _6846_/Y _7101_/Y VDD VSS sg13cmos5l_o21ai_1
X_5294_ _5297_/A _5294_/A _5301_/A VDD VSS sg13cmos5l_xnor2_1
XFILLER_87_516 VDD VSS sg13cmos5l_decap_8
X_7033_ _7164_/B _7061_/B _6840_/Y _7032_/Y VDD VSS sg13cmos5l_o21ai_1
X_4245_ _4294_/B _4245_/A _4245_/B VDD VSS sg13cmos5l_nand2_2
XFILLER_56_903 VDD VSS sg13cmos5l_decap_8
XFILLER_67_240 VDD VSS sg13cmos5l_fill_1
XFILLER_68_752 VDD VSS sg13cmos5l_decap_4
X_4176_ _4212_/B _4176_/A _4176_/B VDD VSS sg13cmos5l_xnor2_1
XFILLER_67_262 VDD VSS sg13cmos5l_fill_2
XFILLER_83_733 VDD VSS sg13cmos5l_decap_8
XFILLER_82_210 VDD VSS sg13cmos5l_decap_4
XFILLER_35_16 VDD VSS sg13cmos5l_decap_4
XFILLER_43_608 VDD VSS sg13cmos5l_decap_8
XFILLER_55_468 VDD VSS sg13cmos5l_fill_2
XFILLER_51_674 VDD VSS sg13cmos5l_decap_8
X_6817_ _7014_/B _6962_/A _6955_/B _6816_/X VDD VSS sg13cmos5l_a21oi_1
XFILLER_50_173 VDD VSS sg13cmos5l_fill_1
XFILLER_51_37 VDD VSS sg13cmos5l_fill_2
X_6748_ _6748_/Y _6997_/B _7004_/A VDD VSS sg13cmos5l_nand2_1
X_6679_ _6681_/B _6688_/A _6679_/B VDD VSS sg13cmos5l_nand2_1
Xoutput880 bank_A_rdata[1] _4162_/A1 VDD VSS sg13cmos5l_buf_1
Xoutput891 bank_A_rdata[2] wire989/X VDD VSS sg13cmos5l_buf_1
XFILLER_78_505 VDD VSS sg13cmos5l_fill_1
XFILLER_59_741 VDD VSS sg13cmos5l_fill_1
XFILLER_78_549 VDD VSS sg13cmos5l_fill_1
XFILLER_76_12 VDD VSS sg13cmos5l_fill_2
XFILLER_47_914 VDD VSS sg13cmos5l_decap_4
XFILLER_58_273 VDD VSS sg13cmos5l_decap_4
XFILLER_62_917 VDD VSS sg13cmos5l_fill_1
XFILLER_73_221 VDD VSS sg13cmos5l_decap_8
XFILLER_73_232 VDD VSS sg13cmos5l_decap_8
XFILLER_61_449 VDD VSS sg13cmos5l_decap_8
XFILLER_41_140 VDD VSS sg13cmos5l_fill_1
Xwire963 wire963/X wire963/A VDD VSS sg13cmos5l_buf_2
Xwire996 _5076_/A wire996/A VDD VSS sg13cmos5l_buf_2
XFILLER_69_538 VDD VSS sg13cmos5l_decap_4
XFILLER_69_549 VDD VSS sg13cmos5l_decap_8
X_4030_ _4050_/B _4176_/A _4030_/B VDD VSS sg13cmos5l_xnor2_1
XFILLER_37_402 VDD VSS sg13cmos5l_fill_1
XFILLER_77_571 VDD VSS sg13cmos5l_fill_2
XFILLER_49_295 VDD VSS sg13cmos5l_decap_4
XFILLER_65_755 VDD VSS sg13cmos5l_fill_2
X_5981_ _5982_/B _6084_/B1 _5981_/A2 _6082_/A1 _5981_/B2 VDD VSS sg13cmos5l_a22oi_1
X_7720_ _7720_/Q _7720_/CLK _7720_/D place748/X VDD VSS sg13cmos5l_dfrbpq_1
X_7651_ _7652_/B _7651_/A _7651_/B VDD VSS sg13cmos5l_nand2_1
XANTENNA_14 input767/X VDD VSS sg13cmos5l_antennanp
X_6602_ _6605_/B _6602_/A _6602_/B VDD VSS sg13cmos5l_nor2_1
X_4863_ _4863_/X _4863_/A _4863_/B VDD VSS sg13cmos5l_and2_1
XANTENNA_25 _7713_/Q VDD VSS sg13cmos5l_antennanp
X_7582_ _7624_/B _7582_/A _7582_/B VDD VSS sg13cmos5l_xnor2_1
X_4794_ _4794_/Y _4794_/A _4782_/B VDD VSS sg13cmos5l_nor2b_1
X_6533_ _6542_/A _6979_/B _6533_/B _6533_/C _6548_/D VDD VSS sg13cmos5l_nor4_1
X_6464_ _6471_/A _6464_/A _6464_/B VDD VSS sg13cmos5l_nand2_2
X_5415_ _5481_/A _5547_/A _5415_/B VDD VSS sg13cmos5l_xnor2_1
X_6395_ _6396_/B _6393_/A _7671_/Q VDD VSS sg13cmos5l_nand2b_1
X_5346_ _5346_/Y _5346_/A VDD VSS sg13cmos5l_inv_1
XFILLER_88_825 VDD VSS sg13cmos5l_decap_4
X_5277_ _5328_/A _5460_/B _5205_/A _5276_/Y VDD VSS sg13cmos5l_a21o_1
X_7016_ _7016_/Y _7112_/B _7016_/B VDD VSS sg13cmos5l_nor2_1
X_4228_ _4229_/A _4228_/A _4228_/B VDD VSS sg13cmos5l_xor2_1
XFILLER_56_711 VDD VSS sg13cmos5l_fill_1
XFILLER_46_48 VDD VSS sg13cmos5l_decap_8
XFILLER_56_744 VDD VSS sg13cmos5l_fill_2
XFILLER_56_766 VDD VSS sg13cmos5l_decap_8
X_4159_ _4159_/Y _5978_/B _5977_/B VDD VSS sg13cmos5l_nand2_1
XFILLER_71_725 VDD VSS sg13cmos5l_decap_8
XFILLER_43_449 VDD VSS sg13cmos5l_decap_8
XFILLER_62_36 VDD VSS sg13cmos5l_fill_2
XFILLER_70_246 VDD VSS sg13cmos5l_fill_2
XFILLER_70_268 VDD VSS sg13cmos5l_fill_1
XFILLER_62_58 VDD VSS sg13cmos5l_fill_2
Xbank_A_sram.gen_ihp_256x32.u_sram_256x32_1070 bank_A_sram.gen_ihp_256x32.u_sram_256x32_1070/L_LO
+ VDD VSS sg13cmos5l_tielo
Xbank_A_sram.gen_ihp_256x32.u_sram_256x32_1081 bank_A_sram.gen_ihp_256x32.u_sram_256x32_1081/L_LO
+ VDD VSS sg13cmos5l_tielo
Xbank_A_sram.gen_ihp_256x32.u_sram_256x32_1092 bank_A_sram.gen_ihp_256x32.u_sram_256x32_1092/L_LO
+ VDD VSS sg13cmos5l_tielo
XFILLER_79_847 VDD VSS sg13cmos5l_decap_8
XFILLER_78_313 VDD VSS sg13cmos5l_fill_2
XFILLER_87_88 VDD VSS sg13cmos5l_decap_4
XFILLER_47_722 VDD VSS sg13cmos5l_fill_1
XFILLER_59_571 VDD VSS sg13cmos5l_fill_2
XFILLER_47_788 VDD VSS sg13cmos5l_fill_2
XFILLER_62_736 VDD VSS sg13cmos5l_decap_8
XFILLER_52_80 VDD VSS sg13cmos5l_decap_8
X_6180_ _7706_/D _6180_/A _6180_/B VDD VSS sg13cmos5l_xnor2_1
X_5062_ _5069_/A _5630_/A _5062_/B VDD VSS sg13cmos5l_xnor2_1
X_4013_ _7663_/D _4013_/A _4015_/A VDD VSS sg13cmos5l_xnor2_1
XFILLER_85_828 VDD VSS sg13cmos5l_decap_8
XFILLER_78_891 VDD VSS sg13cmos5l_decap_8
XFILLER_37_210 VDD VSS sg13cmos5l_decap_4
XFILLER_38_744 VDD VSS sg13cmos5l_fill_2
XFILLER_52_235 VDD VSS sg13cmos5l_fill_1
XFILLER_52_246 VDD VSS sg13cmos5l_fill_2
X_7703_ _7703_/Q clkload8/A _7703_/D place753/X VDD VSS sg13cmos5l_dfrbpq_1
X_5964_ _6010_/A _5964_/A _6005_/A VDD VSS sg13cmos5l_xnor2_1
X_5895_ _5896_/B _6082_/B1 _5981_/A2 _6058_/B1 _5981_/B2 VDD VSS sg13cmos5l_a22oi_1
X_4915_ _4978_/B _5045_/A _4915_/B VDD VSS sg13cmos5l_nor2_1
X_7634_ _7721_/D _7634_/A _7658_/B VDD VSS sg13cmos5l_nand2_2
X_4846_ _4846_/Y _4846_/A _4786_/A VDD VSS sg13cmos5l_nor2b_1
X_7565_ _7566_/B _7619_/A _7619_/B _7620_/C _7565_/D VDD VSS sg13cmos5l_nor4_2
X_4777_ _4781_/A _4837_/B _4777_/B VDD VSS sg13cmos5l_xnor2_1
X_7496_ _7626_/B _7496_/A _7496_/B VDD VSS sg13cmos5l_xnor2_1
Xclkbuf_4_10_0_clk_i_regs _7728_/CLK clkbuf_0_clk_i_regs/X VDD VSS sg13cmos5l_buf_8
X_6447_ _6848_/B _6447_/A _6447_/B VDD VSS sg13cmos5l_nand2_2
X_6378_ _6380_/A _6621_/A _6663_/B VDD VSS sg13cmos5l_nand2_1
X_5329_ _5378_/A _5281_/B _5281_/A _5328_/Y VDD VSS sg13cmos5l_a21oi_1
XFILLER_57_14 VDD VSS sg13cmos5l_fill_1
XFILLER_87_132 VDD VSS sg13cmos5l_fill_1
XFILLER_75_316 VDD VSS sg13cmos5l_fill_2
XFILLER_75_305 VDD VSS sg13cmos5l_decap_8
XFILLER_113_20 VDD VSS sg13cmos5l_fill_1
XFILLER_44_703 VDD VSS sg13cmos5l_fill_1
XFILLER_44_714 VDD VSS sg13cmos5l_fill_2
XFILLER_43_202 VDD VSS sg13cmos5l_fill_2
XFILLER_52_780 VDD VSS sg13cmos5l_decap_8
XFILLER_71_599 VDD VSS sg13cmos5l_decap_8
XFILLER_21_8 VDD VSS sg13cmos5l_decap_8
XFILLER_67_839 VDD VSS sg13cmos5l_decap_8
XFILLER_79_688 VDD VSS sg13cmos5l_decap_8
XFILLER_47_574 VDD VSS sg13cmos5l_decap_8
XFILLER_43_780 VDD VSS sg13cmos5l_decap_8
X_5680_ _5680_/Y _5680_/A _5628_/A VDD VSS sg13cmos5l_nor2b_1
X_4700_ _4703_/A _5012_/A1 _4701_/A _5012_/B1 VDD VSS sg13cmos5l_a21oi_1
XFILLER_97_4 VDD VSS sg13cmos5l_fill_2
X_7350_ _7350_/Y _7157_/Y _7350_/A2 _7328_/B VDD VSS sg13cmos5l_a21oi_1
X_4562_ _4618_/S wire990/X _4493_/Y _4562_/B1 _4920_/B2 VDD VSS sg13cmos5l_a22oi_1
X_7281_ _7306_/A _7274_/Y _7281_/B VDD VSS sg13cmos5l_nand2b_1
X_6301_ _6309_/A _6301_/A _6301_/B VDD VSS sg13cmos5l_nand2_2
X_4493_ _4493_/Y _4495_/A VDD VSS sg13cmos5l_inv_1
X_6232_ _6255_/A _7708_/Q _7707_/Q VDD VSS sg13cmos5l_nor2_2
Xhold2016 _6189_/A _7722_/Q VDD VSS sg13cmos5l_dlygate4sd3_1
X_6163_ _6163_/Y _6163_/A _6141_/B VDD VSS sg13cmos5l_nor2b_1
XFILLER_58_839 VDD VSS sg13cmos5l_decap_8
X_6094_ _6095_/B _6094_/A _6094_/B VDD VSS sg13cmos5l_nand2_1
X_5114_ _5222_/A _5057_/B _5057_/A _5113_/Y VDD VSS sg13cmos5l_a21oi_1
XFILLER_85_625 VDD VSS sg13cmos5l_decap_8
XFILLER_57_338 VDD VSS sg13cmos5l_decap_4
XFILLER_69_187 VDD VSS sg13cmos5l_decap_4
X_5045_ _5109_/B _5045_/A _5045_/B VDD VSS sg13cmos5l_nor2_1
XFILLER_84_168 VDD VSS sg13cmos5l_fill_1
XFILLER_53_511 VDD VSS sg13cmos5l_fill_1
XFILLER_66_894 VDD VSS sg13cmos5l_decap_8
XFILLER_81_875 VDD VSS sg13cmos5l_decap_8
X_5947_ _5956_/A _5947_/A _5947_/B VDD VSS sg13cmos5l_xor2_1
XFILLER_80_374 VDD VSS sg13cmos5l_decap_8
XFILLER_40_227 VDD VSS sg13cmos5l_fill_2
X_7617_ _7618_/C _7560_/B _7617_/B _7617_/C VDD VSS sg13cmos5l_nand3b_1
X_5878_ _5918_/B _5878_/A _5878_/B VDD VSS sg13cmos5l_xnor2_1
X_4829_ _4830_/B _4701_/A _3951_/A _4646_/A _5017_/B2 VDD VSS sg13cmos5l_a22oi_1
X_7548_ _7618_/B _7548_/A _7548_/B VDD VSS sg13cmos5l_xnor2_1
X_7479_ _7480_/B _7605_/A _7603_/B _7605_/B _7605_/C VDD VSS sg13cmos5l_nand4_1
XFILLER_68_46 VDD VSS sg13cmos5l_decap_8
XFILLER_75_113 VDD VSS sg13cmos5l_fill_2
XFILLER_75_135 VDD VSS sg13cmos5l_fill_2
XFILLER_63_308 VDD VSS sg13cmos5l_decap_8
XFILLER_75_157 VDD VSS sg13cmos5l_fill_1
XFILLER_44_500 VDD VSS sg13cmos5l_fill_1
XFILLER_84_89 VDD VSS sg13cmos5l_fill_2
XFILLER_84_67 VDD VSS sg13cmos5l_fill_1
XFILLER_44_566 VDD VSS sg13cmos5l_decap_8
XFILLER_72_886 VDD VSS sg13cmos5l_decap_8
XFILLER_69_8 VDD VSS sg13cmos5l_fill_2
XFILLER_66_168 VDD VSS sg13cmos5l_decap_8
Xinput780 input780/X bank_A_wdata[25] VDD VSS sg13cmos5l_buf_1
Xinput791 input791/X bank_A_wdata[6] VDD VSS sg13cmos5l_buf_1
XFILLER_66_179 VDD VSS sg13cmos5l_fill_1
XFILLER_75_680 VDD VSS sg13cmos5l_decap_8
XFILLER_63_875 VDD VSS sg13cmos5l_decap_8
X_6850_ _7034_/A _6945_/A _6974_/B _6849_/X VDD VSS sg13cmos5l_a21oi_1
XFILLER_50_514 VDD VSS sg13cmos5l_fill_2
X_6781_ _7483_/B _6899_/B _6899_/A VDD VSS sg13cmos5l_nand2_2
X_5801_ _5802_/B _5801_/A1 _5981_/A2 _5801_/B1 _5981_/B2 VDD VSS sg13cmos5l_a22oi_1
X_5732_ _5735_/A _5736_/C _5786_/B VDD VSS sg13cmos5l_nand2_1
X_3993_ _4037_/A _3993_/A _3993_/B VDD VSS sg13cmos5l_nand2_1
X_5663_ _5782_/A _5665_/B _5665_/A VDD VSS sg13cmos5l_nor2_1
X_7402_ _7413_/B _7503_/A _7578_/A VDD VSS sg13cmos5l_nand2_1
X_5594_ _5598_/A _5594_/A _5655_/A VDD VSS sg13cmos5l_xnor2_1
X_4614_ _4671_/A _4614_/A _4614_/B VDD VSS sg13cmos5l_nand2_1
X_7333_ _7333_/Y _7058_/Y _7405_/A2 _7328_/B VDD VSS sg13cmos5l_a21oi_1
X_4545_ _4547_/C _4545_/A _4611_/A VDD VSS sg13cmos5l_xnor2_1
Xrebuffer1411 rebuffer1411/X rebuffer1412/X VDD VSS sg13cmos5l_buf_1
Xrebuffer1400 _7657_/A _7609_/Y VDD VSS sg13cmos5l_buf_8
X_7264_ _7265_/B _7296_/A _7264_/B VDD VSS sg13cmos5l_nor2_1
X_4476_ _4479_/B _4410_/A _4476_/B VDD VSS sg13cmos5l_nand2b_1
Xrebuffer1444 rebuffer1444/X rebuffer1445/X VDD VSS sg13cmos5l_buf_1
Xrebuffer1433 rebuffer1433/X rebuffer1434/X VDD VSS sg13cmos5l_buf_1
Xrebuffer1422 _6397_/A _7707_/Q VDD VSS sg13cmos5l_buf_1
X_7195_ _7195_/X _7277_/A _7195_/B VDD VSS sg13cmos5l_and2_1
X_6215_ _6215_/Y _6227_/A _6215_/B VDD VSS sg13cmos5l_nand2_1
Xfanout936 _5244_/B1 _4930_/A1 VDD VSS sg13cmos5l_buf_1
Xfanout947 _5909_/B1 _5575_/B1 VDD VSS sg13cmos5l_buf_1
Xfanout958 _4739_/B1 _4859_/B1 VDD VSS sg13cmos5l_buf_1
Xrebuffer1455 _7558_/B _7304_/A VDD VSS sg13cmos5l_buf_1
X_6146_ _6166_/A _6122_/B _6144_/Y _6145_/Y VDD VSS sg13cmos5l_a21oi_1
XFILLER_85_400 VDD VSS sg13cmos5l_decap_4
XFILLER_38_38 VDD VSS sg13cmos5l_fill_2
XFILLER_58_658 VDD VSS sg13cmos5l_fill_2
XFILLER_73_617 VDD VSS sg13cmos5l_fill_1
X_6077_ _6078_/B _6077_/A _6077_/B VDD VSS sg13cmos5l_nand2_2
XFILLER_85_466 VDD VSS sg13cmos5l_fill_1
XFILLER_39_883 VDD VSS sg13cmos5l_decap_8
XFILLER_54_831 VDD VSS sg13cmos5l_decap_8
XFILLER_73_628 VDD VSS sg13cmos5l_decap_8
X_5028_ _5029_/B _5096_/B _5096_/A VDD VSS sg13cmos5l_xor2_1
XFILLER_38_393 VDD VSS sg13cmos5l_decap_8
XFILLER_54_48 VDD VSS sg13cmos5l_decap_8
XFILLER_65_190 VDD VSS sg13cmos5l_decap_8
XFILLER_81_672 VDD VSS sg13cmos5l_decap_8
XFILLER_53_385 VDD VSS sg13cmos5l_fill_1
X_6979_ _6979_/Y _6979_/A _6979_/B _6979_/C _6979_/D VDD VSS sg13cmos5l_nand4_1
XFILLER_79_34 VDD VSS sg13cmos5l_fill_1
XFILLER_49_614 VDD VSS sg13cmos5l_fill_1
XFILLER_48_146 VDD VSS sg13cmos5l_fill_2
XFILLER_64_617 VDD VSS sg13cmos5l_fill_2
XFILLER_45_820 VDD VSS sg13cmos5l_decap_8
XFILLER_45_897 VDD VSS sg13cmos5l_decap_8
XFILLER_60_867 VDD VSS sg13cmos5l_decap_8
XFILLER_5_20 VDD VSS sg13cmos5l_fill_1
X_4330_ _4331_/B _4218_/A _4592_/A2 _4171_/A _4531_/B2 VDD VSS sg13cmos5l_a22oi_1
X_4261_ _4268_/A _4374_/A _4261_/B VDD VSS sg13cmos5l_xnor2_1
XFILLER_68_901 VDD VSS sg13cmos5l_decap_8
X_6000_ _6001_/A _5960_/A _5998_/Y _5999_/Y VDD VSS sg13cmos5l_o21ai_1
XFILLER_67_411 VDD VSS sg13cmos5l_decap_8
XFILLER_67_422 VDD VSS sg13cmos5l_fill_2
X_4192_ _4233_/B _4192_/A VDD VSS sg13cmos5l_inv_1
XFILLER_83_915 VDD VSS sg13cmos5l_fill_2
XFILLER_82_436 VDD VSS sg13cmos5l_fill_2
XFILLER_54_138 VDD VSS sg13cmos5l_fill_2
X_6902_ _6903_/A _6724_/A _6901_/A _6901_/Y VDD VSS sg13cmos5l_a21oi_1
XFILLER_50_300 VDD VSS sg13cmos5l_fill_1
Xplace650 _5575_/B1 _5013_/A VDD VSS sg13cmos5l_buf_1
X_6833_ _6834_/B _7144_/B _6833_/B VDD VSS sg13cmos5l_nor2_1
XFILLER_50_322 VDD VSS sg13cmos5l_decap_8
Xplace661 _4878_/A1 _4697_/B1 VDD VSS sg13cmos5l_buf_1
Xplace672 _7302_/A1 _7712_/Q VDD VSS sg13cmos5l_buf_1
Xplace683 _6981_/A _6321_/B VDD VSS sg13cmos5l_buf_1
XFILLER_51_867 VDD VSS sg13cmos5l_decap_8
Xplace694 _7168_/B _7142_/B VDD VSS sg13cmos5l_buf_1
X_6764_ _6764_/Y _6764_/A _6764_/B VDD VSS sg13cmos5l_xnor2_1
X_3976_ _3977_/C _5335_/B _3976_/B _3976_/C VDD VSS sg13cmos5l_nor3_1
XFILLER_50_399 VDD VSS sg13cmos5l_decap_4
X_6695_ _6779_/A _6780_/A _6780_/B VDD VSS sg13cmos5l_nand2_2
X_5715_ _5718_/A _5758_/A _5753_/B VDD VSS sg13cmos5l_xnor2_1
X_5646_ _5716_/A _5710_/B _5646_/B VDD VSS sg13cmos5l_xnor2_1
X_5577_ _5578_/B _5626_/A _5626_/B VDD VSS sg13cmos5l_xor2_1
X_7316_ _7529_/A _7331_/B _7324_/A VDD VSS sg13cmos5l_xnor2_1
X_7247_ _7247_/Y _7057_/B _7276_/S _7246_/Y VDD VSS sg13cmos5l_a21oi_1
X_4459_ _4460_/B _4539_/B _4539_/A VDD VSS sg13cmos5l_xor2_1
XFILLER_59_912 VDD VSS sg13cmos5l_decap_4
Xrebuffer1252 _7638_/A rebuffer1293/X VDD VSS sg13cmos5l_buf_1
Xrebuffer1263 rebuffer1263/X rebuffer1271/X VDD VSS sg13cmos5l_buf_1
Xrebuffer1274 rebuffer1274/X rebuffer1275/X VDD VSS sg13cmos5l_buf_1
Xrebuffer1285 rebuffer1285/X rebuffer1286/X VDD VSS sg13cmos5l_buf_1
X_7178_ _7178_/X _7055_/X _7047_/Y _7178_/S VDD VSS sg13cmos5l_mux2_1
XFILLER_86_731 VDD VSS sg13cmos5l_decap_8
XFILLER_58_455 VDD VSS sg13cmos5l_decap_8
Xrebuffer1296 rebuffer1296/X rebuffer1297/X VDD VSS sg13cmos5l_buf_1
X_6129_ _6129_/Y _6129_/A _6129_/B VDD VSS sg13cmos5l_nand2_1
XFILLER_85_230 VDD VSS sg13cmos5l_fill_1
XFILLER_65_25 VDD VSS sg13cmos5l_decap_8
XFILLER_73_436 VDD VSS sg13cmos5l_decap_8
XFILLER_85_274 VDD VSS sg13cmos5l_fill_1
XFILLER_121_20 VDD VSS sg13cmos5l_fill_1
XFILLER_42_823 VDD VSS sg13cmos5l_decap_8
XFILLER_54_650 VDD VSS sg13cmos5l_fill_2
XFILLER_54_694 VDD VSS sg13cmos5l_fill_1
Xmax_cap1017 _4218_/A _4520_/B1 VDD VSS sg13cmos5l_buf_2
XFILLER_64_458 VDD VSS sg13cmos5l_fill_1
XFILLER_44_182 VDD VSS sg13cmos5l_decap_8
XFILLER_45_683 VDD VSS sg13cmos5l_decap_4
XFILLER_60_631 VDD VSS sg13cmos5l_fill_2
X_5500_ _5595_/B _5500_/A _5500_/B VDD VSS sg13cmos5l_xor2_1
X_6480_ _6482_/A _6841_/B _6841_/A VDD VSS sg13cmos5l_nand2_2
X_5431_ _5432_/B _5622_/B1 _5623_/A2 _5557_/B1 _5687_/B2 VDD VSS sg13cmos5l_a22oi_1
X_5362_ _7687_/D _5362_/A _5362_/B VDD VSS sg13cmos5l_xnor2_1
Xclkbuf_4_15_0_clk_i_regs clkload9/A clkbuf_0_clk_i_regs/X VDD VSS sg13cmos5l_buf_8
X_7101_ _7101_/Y _7101_/A _7164_/A VDD VSS sg13cmos5l_nand2_1
X_7032_ _7032_/Y _7032_/A _7071_/B VDD VSS sg13cmos5l_nand2_1
X_5293_ _5301_/A _5225_/B _5242_/A _5292_/X VDD VSS sg13cmos5l_a21oi_1
XFILLER_19_18 VDD VSS sg13cmos5l_fill_2
XFILLER_68_720 VDD VSS sg13cmos5l_fill_1
X_4244_ _4245_/A _4241_/Y _4244_/B VDD VSS sg13cmos5l_nand2b_1
X_4175_ _4176_/B _4085_/A _4175_/A2 _4056_/A _4175_/B2 VDD VSS sg13cmos5l_a22oi_1
XFILLER_83_712 VDD VSS sg13cmos5l_decap_8
XFILLER_55_447 VDD VSS sg13cmos5l_decap_8
XFILLER_71_907 VDD VSS sg13cmos5l_decap_8
XFILLER_83_789 VDD VSS sg13cmos5l_decap_8
XFILLER_82_266 VDD VSS sg13cmos5l_fill_2
XFILLER_51_620 VDD VSS sg13cmos5l_decap_8
XFILLER_50_130 VDD VSS sg13cmos5l_decap_4
X_6816_ _6816_/X _6816_/A _6968_/B VDD VSS sg13cmos5l_and2_1
XFILLER_51_27 VDD VSS sg13cmos5l_fill_2
X_3959_ _3972_/B _3964_/C VDD VSS sg13cmos5l_inv_1
X_6678_ _6721_/B _6723_/B _6678_/B VDD VSS sg13cmos5l_nand2_2
X_5629_ _5653_/A _5629_/A _5629_/B VDD VSS sg13cmos5l_xor2_1
Xoutput870 bank_A_rdata[10] _4218_/A VDD VSS sg13cmos5l_buf_1
Xoutput881 bank_A_rdata[20] wire1000/A VDD VSS sg13cmos5l_buf_1
Xoutput892 bank_A_rdata[30] wire988/A VDD VSS sg13cmos5l_buf_1
XFILLER_78_539 VDD VSS sg13cmos5l_fill_1
XFILLER_76_57 VDD VSS sg13cmos5l_fill_1
XFILLER_73_211 VDD VSS sg13cmos5l_fill_2
XFILLER_61_406 VDD VSS sg13cmos5l_fill_1
XFILLER_42_653 VDD VSS sg13cmos5l_fill_2
Xwire964 wire964/X wire964/A VDD VSS sg13cmos5l_buf_2
Xwire975 wire975/X wire975/A VDD VSS sg13cmos5l_buf_8
Xwire986 _3975_/A wire986/A VDD VSS sg13cmos5l_buf_4
Xwire997 _5013_/A wire997/A VDD VSS sg13cmos5l_buf_2
XFILLER_49_230 VDD VSS sg13cmos5l_decap_8
X_5980_ _6057_/A _6025_/B VDD VSS sg13cmos5l_inv_1
XFILLER_80_726 VDD VSS sg13cmos5l_decap_8
X_4931_ _4938_/A _4931_/A _4931_/B VDD VSS sg13cmos5l_xnor2_1
XFILLER_80_759 VDD VSS sg13cmos5l_decap_8
XFILLER_80_737 VDD VSS sg13cmos5l_fill_1
X_7650_ _7652_/A _7650_/A _7650_/B VDD VSS sg13cmos5l_nand2_1
X_4862_ _4865_/A _4919_/S _4862_/B VDD VSS sg13cmos5l_xnor2_1
XFILLER_60_483 VDD VSS sg13cmos5l_fill_2
X_6601_ _6757_/B _6601_/A _6601_/B VDD VSS sg13cmos5l_nand2_2
XANTENNA_15 input774/X VDD VSS sg13cmos5l_antennanp
XANTENNA_26 _7713_/Q VDD VSS sg13cmos5l_antennanp
X_7581_ _7582_/B _7585_/A _7429_/B _7499_/B VDD VSS sg13cmos5l_o21ai_1
X_4793_ _4843_/A _4793_/A _4793_/B VDD VSS sg13cmos5l_nor2_1
XFILLER_21_19 VDD VSS sg13cmos5l_fill_2
X_6532_ _6873_/B _6532_/A _6532_/B VDD VSS sg13cmos5l_nand2_2
X_6463_ _6464_/A _6847_/B _6847_/A VDD VSS sg13cmos5l_nand2_2
X_5414_ _5415_/B _5477_/B _5477_/A VDD VSS sg13cmos5l_xor2_1
X_6394_ _6396_/A _6826_/B _6826_/A VDD VSS sg13cmos5l_nand2_2
X_5345_ _5349_/A _5407_/B _5345_/B VDD VSS sg13cmos5l_xnor2_1
X_5276_ _5276_/Y _5276_/A _5276_/B VDD VSS sg13cmos5l_nor2_1
XFILLER_88_848 VDD VSS sg13cmos5l_decap_8
X_7015_ _7016_/B _6829_/B _7018_/B _7014_/Y VDD VSS sg13cmos5l_a21oi_1
X_4227_ _4228_/B _4286_/B _4286_/A VDD VSS sg13cmos5l_xor2_1
XFILLER_55_233 VDD VSS sg13cmos5l_decap_8
X_4158_ _4158_/Y _5978_/B _4158_/B VDD VSS sg13cmos5l_nor2_1
XFILLER_83_520 VDD VSS sg13cmos5l_fill_1
X_4089_ _4090_/B _4023_/A _4175_/A2 _4003_/A _4175_/B2 VDD VSS sg13cmos5l_a22oi_1
XFILLER_83_586 VDD VSS sg13cmos5l_decap_8
XFILLER_70_236 VDD VSS sg13cmos5l_fill_1
Xbank_A_sram.gen_ihp_256x32.u_sram_256x32_1060 bank_A_sram.gen_ihp_256x32.u_sram_256x32_1060/L_LO
+ VDD VSS sg13cmos5l_tielo
Xbank_A_sram.gen_ihp_256x32.u_sram_256x32_1071 bank_A_sram.gen_ihp_256x32.u_sram_256x32_1071/L_LO
+ VDD VSS sg13cmos5l_tielo
XFILLER_79_826 VDD VSS sg13cmos5l_decap_8
Xbank_A_sram.gen_ihp_256x32.u_sram_256x32_1082 bank_A_sram.gen_ihp_256x32.u_sram_256x32_1082/L_LO
+ VDD VSS sg13cmos5l_tielo
Xbank_A_sram.gen_ihp_256x32.u_sram_256x32_1093 bank_A_sram.gen_ihp_256x32.u_sram_256x32_1093/L_LO
+ VDD VSS sg13cmos5l_tielo
XFILLER_87_892 VDD VSS sg13cmos5l_decap_8
XFILLER_74_553 VDD VSS sg13cmos5l_decap_8
XFILLER_74_597 VDD VSS sg13cmos5l_fill_2
XFILLER_61_247 VDD VSS sg13cmos5l_decap_4
X_5130_ _5137_/A _5630_/A _5130_/B VDD VSS sg13cmos5l_xnor2_1
X_5061_ _5062_/B _5370_/B1 _5380_/A2 _5310_/B1 _5188_/B2 VDD VSS sg13cmos5l_a22oi_1
XFILLER_85_807 VDD VSS sg13cmos5l_decap_8
X_4012_ _4015_/A _4643_/A _4012_/B VDD VSS sg13cmos5l_xor2_1
XFILLER_78_870 VDD VSS sg13cmos5l_decap_8
XFILLER_37_200 VDD VSS sg13cmos5l_fill_2
XFILLER_16_19 VDD VSS sg13cmos5l_fill_2
XFILLER_52_214 VDD VSS sg13cmos5l_decap_8
XFILLER_65_597 VDD VSS sg13cmos5l_decap_8
X_5963_ _6005_/A _5921_/B _5961_/Y _5962_/Y VDD VSS sg13cmos5l_a21oi_1
XFILLER_53_759 VDD VSS sg13cmos5l_decap_8
X_7702_ _7702_/Q _7702_/CLK _7702_/D place751/X VDD VSS sg13cmos5l_dfrbpq_1
X_4914_ _4972_/A _4914_/A _4909_/A VDD VSS sg13cmos5l_nor2b_1
X_5894_ _5961_/A _5866_/B _5866_/A _5893_/Y VDD VSS sg13cmos5l_a21oi_1
X_4845_ _4849_/A _4845_/A VDD VSS sg13cmos5l_inv_1
X_7564_ _7620_/C _7563_/Y _7564_/B VDD VSS sg13cmos5l_nand2b_1
X_4776_ _4777_/B _4776_/A _4838_/B VDD VSS sg13cmos5l_xor2_1
X_6515_ _6883_/B _6515_/A _6515_/B VDD VSS sg13cmos5l_nand2_2
X_7495_ _7628_/A _7495_/A _7492_/A VDD VSS sg13cmos5l_nor2b_1
X_6446_ _6447_/B _6444_/B _7676_/Q VDD VSS sg13cmos5l_nand2b_1
X_6377_ _6663_/B _6407_/A _6377_/B VDD VSS sg13cmos5l_nor2_1
XFILLER_88_601 VDD VSS sg13cmos5l_fill_2
X_5328_ _5328_/Y _5328_/A _5328_/B VDD VSS sg13cmos5l_nor2_1
XFILLER_69_892 VDD VSS sg13cmos5l_decap_8
XFILLER_84_884 VDD VSS sg13cmos5l_decap_8
XFILLER_83_372 VDD VSS sg13cmos5l_fill_1
XFILLER_83_361 VDD VSS sg13cmos5l_decap_8
XFILLER_73_69 VDD VSS sg13cmos5l_fill_2
XFILLER_0_0 VDD VSS sg13cmos5l_decap_8
XFILLER_79_667 VDD VSS sg13cmos5l_decap_8
XFILLER_67_818 VDD VSS sg13cmos5l_decap_8
XFILLER_14_8 VDD VSS sg13cmos5l_decap_8
XFILLER_59_380 VDD VSS sg13cmos5l_decap_4
XFILLER_78_188 VDD VSS sg13cmos5l_fill_2
XFILLER_74_383 VDD VSS sg13cmos5l_decap_8
XFILLER_75_884 VDD VSS sg13cmos5l_decap_8
X_4630_ _4637_/A _5060_/A _4630_/B VDD VSS sg13cmos5l_xnor2_1
X_6300_ _6301_/B _6300_/A_N _7662_/Q VDD VSS sg13cmos5l_nand2b_1
X_7280_ _7281_/B _7299_/A1 _7276_/X _7279_/Y VDD VSS sg13cmos5l_o21ai_1
X_4492_ _4560_/A _4492_/A _4492_/B VDD VSS sg13cmos5l_xnor2_1
XFILLER_69_100 VDD VSS sg13cmos5l_decap_8
X_6162_ _6165_/A _6175_/B _6159_/Y _6160_/Y _6161_/Y VDD VSS sg13cmos5l_a22oi_1
XFILLER_33_0 VDD VSS sg13cmos5l_fill_1
XFILLER_69_144 VDD VSS sg13cmos5l_fill_1
Xhold2017 _6207_/A _7728_/Q VDD VSS sg13cmos5l_dlygate4sd3_1
X_5113_ _5113_/Y _5113_/A _5056_/A VDD VSS sg13cmos5l_nor2b_1
XFILLER_69_166 VDD VSS sg13cmos5l_fill_1
X_6093_ _6095_/A _6093_/A _6093_/B VDD VSS sg13cmos5l_nand2_1
XFILLER_85_604 VDD VSS sg13cmos5l_decap_8
XFILLER_38_520 VDD VSS sg13cmos5l_decap_4
XFILLER_66_873 VDD VSS sg13cmos5l_decap_8
XFILLER_84_158 VDD VSS sg13cmos5l_fill_2
XFILLER_53_534 VDD VSS sg13cmos5l_decap_8
XFILLER_81_854 VDD VSS sg13cmos5l_decap_8
XFILLER_80_342 VDD VSS sg13cmos5l_fill_1
XFILLER_80_320 VDD VSS sg13cmos5l_fill_2
XFILLER_41_718 VDD VSS sg13cmos5l_decap_8
X_5946_ _5947_/A _5946_/A _5990_/A VDD VSS sg13cmos5l_xnor2_1
XFILLER_43_39 VDD VSS sg13cmos5l_decap_8
X_5877_ _5878_/B _5816_/B _5816_/A _5876_/X VDD VSS sg13cmos5l_a21o_1
X_7616_ _7617_/C _7616_/A _7616_/B _7616_/C VDD VSS sg13cmos5l_nor3_1
X_4828_ _4882_/A _4947_/B _4766_/A _4827_/Y VDD VSS sg13cmos5l_a21o_1
X_7547_ _7548_/B _7547_/A _7550_/A VDD VSS sg13cmos5l_nand2_1
X_4759_ _4759_/Y _4759_/A _4759_/B VDD VSS sg13cmos5l_nor2_1
X_7478_ _7605_/C _7603_/A _7478_/B VDD VSS sg13cmos5l_xnor2_1
X_6429_ _6431_/B _6541_/A _6429_/B VDD VSS sg13cmos5l_nand2_1
XFILLER_88_442 VDD VSS sg13cmos5l_fill_1
XFILLER_49_829 VDD VSS sg13cmos5l_decap_8
XFILLER_75_147 VDD VSS sg13cmos5l_fill_1
XFILLER_57_895 VDD VSS sg13cmos5l_decap_8
XFILLER_84_79 VDD VSS sg13cmos5l_decap_4
XFILLER_84_681 VDD VSS sg13cmos5l_decap_8
XFILLER_56_394 VDD VSS sg13cmos5l_fill_1
XFILLER_71_320 VDD VSS sg13cmos5l_fill_2
XFILLER_72_865 VDD VSS sg13cmos5l_decap_8
XFILLER_83_180 VDD VSS sg13cmos5l_fill_2
XFILLER_44_589 VDD VSS sg13cmos5l_fill_1
XFILLER_40_795 VDD VSS sg13cmos5l_decap_8
XFILLER_79_420 VDD VSS sg13cmos5l_fill_1
XFILLER_39_306 VDD VSS sg13cmos5l_fill_2
XFILLER_67_626 VDD VSS sg13cmos5l_fill_2
XFILLER_39_339 VDD VSS sg13cmos5l_fill_2
XFILLER_58_80 VDD VSS sg13cmos5l_fill_2
Xinput770 input770/X bank_A_wdata[16] VDD VSS sg13cmos5l_buf_1
Xinput781 input781/X bank_A_wdata[26] VDD VSS sg13cmos5l_buf_1
Xinput792 input792/X bank_A_wdata[7] VDD VSS sg13cmos5l_buf_1
XFILLER_48_884 VDD VSS sg13cmos5l_decap_8
XFILLER_82_629 VDD VSS sg13cmos5l_decap_8
XFILLER_81_106 VDD VSS sg13cmos5l_fill_1
XFILLER_63_854 VDD VSS sg13cmos5l_decap_8
X_6780_ _6899_/A _6780_/A _6780_/B _6780_/C VDD VSS sg13cmos5l_nand3_1
X_5800_ _5854_/A _5800_/A _5800_/B VDD VSS sg13cmos5l_xor2_1
X_5731_ _5786_/B _5731_/A _5731_/B _5731_/C VDD VSS sg13cmos5l_nand3_1
X_5662_ _5665_/A _5662_/A VDD VSS sg13cmos5l_inv_1
X_7401_ _7578_/A _7570_/B _7409_/B VDD VSS sg13cmos5l_xnor2_1
X_5593_ _5655_/A _5593_/A _5654_/A VDD VSS sg13cmos5l_xor2_1
X_4613_ _7675_/D _4613_/A _4613_/B VDD VSS sg13cmos5l_xor2_1
X_7332_ _7525_/A _7332_/A _7548_/A _7550_/A VDD VSS sg13cmos5l_nand3_1
X_4544_ _4611_/A _4544_/A _4549_/A VDD VSS sg13cmos5l_xnor2_1
X_7263_ _7263_/Y _7109_/B _7276_/S _7262_/X VDD VSS sg13cmos5l_a21oi_1
Xrebuffer1401 _6851_/B _6445_/A VDD VSS sg13cmos5l_buf_1
X_6214_ _6214_/Y _6210_/A _6183_/Y _6213_/Y VDD VSS sg13cmos5l_o21ai_1
X_4475_ _4479_/A _4475_/A _4475_/B VDD VSS sg13cmos5l_nand2_1
Xrebuffer1434 rebuffer1434/X rebuffer1435/X VDD VSS sg13cmos5l_buf_1
Xrebuffer1423 _6249_/A _7707_/Q VDD VSS sg13cmos5l_buf_1
Xrebuffer1412 rebuffer1412/X rebuffer1413/X VDD VSS sg13cmos5l_buf_1
X_7194_ _7277_/A _7187_/A _7063_/Y _7193_/Y VDD VSS sg13cmos5l_a21oi_1
Xfanout937 _5310_/B1 _4878_/A1 VDD VSS sg13cmos5l_buf_1
Xfanout948 _5949_/B1 _5760_/B1 VDD VSS sg13cmos5l_buf_1
Xrebuffer1456 _7498_/A _7432_/A VDD VSS sg13cmos5l_buf_1
Xrebuffer1445 rebuffer1445/X rebuffer1446/X VDD VSS sg13cmos5l_buf_1
X_6145_ _6145_/Y _6145_/A _6145_/B VDD VSS sg13cmos5l_nor2_1
XFILLER_86_913 VDD VSS sg13cmos5l_decap_4
XFILLER_58_626 VDD VSS sg13cmos5l_decap_8
XFILLER_58_637 VDD VSS sg13cmos5l_fill_1
Xfanout959 _4800_/B1 _4920_/B1 VDD VSS sg13cmos5l_buf_8
X_6076_ _6077_/B _6076_/A _6076_/B VDD VSS sg13cmos5l_nand2_1
XFILLER_39_862 VDD VSS sg13cmos5l_decap_8
X_5027_ _5096_/A _5025_/Y _4957_/B _5026_/Y VDD VSS sg13cmos5l_o21ai_1
XFILLER_85_445 VDD VSS sg13cmos5l_fill_1
XFILLER_54_38 VDD VSS sg13cmos5l_fill_2
XFILLER_81_651 VDD VSS sg13cmos5l_decap_8
XFILLER_53_353 VDD VSS sg13cmos5l_decap_8
XFILLER_54_887 VDD VSS sg13cmos5l_decap_8
XFILLER_41_548 VDD VSS sg13cmos5l_fill_2
X_6978_ _6979_/D _6800_/B _6978_/B VDD VSS sg13cmos5l_nand2b_1
XFILLER_80_172 VDD VSS sg13cmos5l_fill_1
XFILLER_70_26 VDD VSS sg13cmos5l_fill_1
X_5929_ _5930_/B _5966_/A _5884_/B _5928_/Y VDD VSS sg13cmos5l_o21ai_1
XFILLER_70_37 VDD VSS sg13cmos5l_fill_1
XFILLER_119_20 VDD VSS sg13cmos5l_fill_1
XFILLER_79_24 VDD VSS sg13cmos5l_decap_4
XFILLER_88_261 VDD VSS sg13cmos5l_fill_1
XFILLER_48_125 VDD VSS sg13cmos5l_fill_1
Xrebuffer1990 rebuffer1990/X rebuffer1991/X VDD VSS sg13cmos5l_buf_1
XFILLER_88_294 VDD VSS sg13cmos5l_fill_2
XFILLER_45_876 VDD VSS sg13cmos5l_decap_8
XFILLER_72_651 VDD VSS sg13cmos5l_decap_4
XFILLER_72_673 VDD VSS sg13cmos5l_decap_8
XFILLER_44_386 VDD VSS sg13cmos5l_fill_1
XFILLER_60_846 VDD VSS sg13cmos5l_decap_8
XFILLER_60_81 VDD VSS sg13cmos5l_fill_1
X_4260_ _4261_/B _3965_/B _4203_/A _4303_/B _4686_/B2 VDD VSS sg13cmos5l_a22oi_1
X_4191_ _7668_/D _4191_/A _4191_/B VDD VSS sg13cmos5l_xnor2_1
XFILLER_79_283 VDD VSS sg13cmos5l_fill_2
XFILLER_55_629 VDD VSS sg13cmos5l_decap_8
XFILLER_48_692 VDD VSS sg13cmos5l_fill_1
XFILLER_63_640 VDD VSS sg13cmos5l_decap_8
X_6901_ _6901_/Y _6901_/A _6901_/B VDD VSS sg13cmos5l_nor2_1
Xplace640 _4675_/B1 _3975_/A VDD VSS sg13cmos5l_buf_1
X_6832_ _6833_/B _7142_/B _7114_/A _6831_/Y VDD VSS sg13cmos5l_o21ai_1
XFILLER_51_846 VDD VSS sg13cmos5l_decap_8
Xplace651 _5508_/B1 _4946_/A VDD VSS sg13cmos5l_buf_1
Xplace662 _4930_/A1 _4642_/B1 VDD VSS sg13cmos5l_buf_1
Xplace673 _7297_/A _7141_/A VDD VSS sg13cmos5l_buf_1
XFILLER_50_356 VDD VSS sg13cmos5l_decap_8
Xplace684 _6321_/B _6499_/C VDD VSS sg13cmos5l_buf_1
Xplace695 _7142_/B _7112_/B VDD VSS sg13cmos5l_buf_1
X_3975_ _3976_/C _3975_/A VDD VSS sg13cmos5l_inv_1
XFILLER_50_378 VDD VSS sg13cmos5l_fill_2
X_6694_ _6780_/B _6692_/B _7705_/Q VDD VSS sg13cmos5l_nand2b_2
X_5714_ _5753_/B _5810_/B _5714_/B VDD VSS sg13cmos5l_xnor2_1
X_5645_ _5646_/B _5645_/A _5645_/B VDD VSS sg13cmos5l_xnor2_1
X_5576_ _5626_/B _5702_/A _5576_/B VDD VSS sg13cmos5l_xnor2_1
X_7315_ _7324_/A _7327_/A _7315_/A2 _7314_/Y VDD VSS sg13cmos5l_o21ai_1
X_4527_ _4581_/A _4525_/B _4446_/A _4526_/Y VDD VSS sg13cmos5l_a21o_1
X_7246_ _7246_/Y _7246_/A _7246_/B VDD VSS sg13cmos5l_nor2_1
X_4458_ _4539_/A _4397_/A _4456_/Y _4457_/Y VDD VSS sg13cmos5l_o21ai_1
XFILLER_49_49 VDD VSS sg13cmos5l_fill_1
Xrebuffer1253 _7651_/A _7151_/A VDD VSS sg13cmos5l_buf_1
X_7177_ _7203_/A _7177_/A _7177_/B _7650_/B VDD VSS sg13cmos5l_nand3_1
Xrebuffer1264 _6248_/A _7708_/Q VDD VSS sg13cmos5l_buf_8
Xrebuffer1275 rebuffer1275/X rebuffer1276/X VDD VSS sg13cmos5l_buf_1
Xrebuffer1286 rebuffer1286/X rebuffer1287/X VDD VSS sg13cmos5l_buf_1
X_6128_ _6155_/B _6168_/A _6128_/B VDD VSS sg13cmos5l_xnor2_1
X_4389_ _4390_/C _4389_/A VDD VSS sg13cmos5l_inv_1
XFILLER_86_710 VDD VSS sg13cmos5l_decap_8
Xrebuffer1297 rebuffer1297/X rebuffer1298/X VDD VSS sg13cmos5l_buf_1
XFILLER_85_242 VDD VSS sg13cmos5l_fill_2
XFILLER_73_415 VDD VSS sg13cmos5l_fill_2
X_6059_ _6060_/B _6084_/B1 _6084_/A2 _6082_/A1 _6084_/B2 VDD VSS sg13cmos5l_a22oi_1
XFILLER_86_787 VDD VSS sg13cmos5l_decap_8
XFILLER_85_286 VDD VSS sg13cmos5l_fill_2
XFILLER_42_802 VDD VSS sg13cmos5l_decap_8
XFILLER_60_109 VDD VSS sg13cmos5l_decap_8
XFILLER_41_334 VDD VSS sg13cmos5l_fill_1
XFILLER_42_879 VDD VSS sg13cmos5l_decap_8
XFILLER_81_58 VDD VSS sg13cmos5l_fill_1
XFILLER_50_890 VDD VSS sg13cmos5l_decap_8
Xmax_cap1007 _4524_/A _4820_/B1 VDD VSS sg13cmos5l_buf_2
XFILLER_100_0 VDD VSS sg13cmos5l_fill_1
XFILLER_49_423 VDD VSS sg13cmos5l_decap_4
XFILLER_39_93 VDD VSS sg13cmos5l_fill_2
XFILLER_49_456 VDD VSS sg13cmos5l_decap_4
XFILLER_77_743 VDD VSS sg13cmos5l_decap_8
XFILLER_64_415 VDD VSS sg13cmos5l_decap_8
XFILLER_76_253 VDD VSS sg13cmos5l_decap_8
XFILLER_45_640 VDD VSS sg13cmos5l_decap_8
XFILLER_44_150 VDD VSS sg13cmos5l_decap_8
XFILLER_45_673 VDD VSS sg13cmos5l_decap_4
XFILLER_45_695 VDD VSS sg13cmos5l_fill_2
X_5430_ _5492_/S _5493_/B1 _5493_/A2 _5430_/B1 _4496_/Y VDD VSS sg13cmos5l_a22oi_1
X_5361_ _5362_/B _5359_/Y _5361_/B VDD VSS sg13cmos5l_nand2b_1
X_7100_ _7262_/A _6775_/B _7191_/B _7099_/Y VDD VSS sg13cmos5l_a21oi_1
X_5292_ _5292_/X _5292_/A _5292_/B VDD VSS sg13cmos5l_and2_1
X_4312_ _4369_/A _4312_/A _4312_/B VDD VSS sg13cmos5l_xnor2_1
X_7031_ _7031_/Y _7030_/B _7027_/Y _7030_/Y VDD VSS sg13cmos5l_o21ai_1
X_4243_ _4244_/B _4243_/A _4243_/B _4243_/C VDD VSS sg13cmos5l_nand3_1
XFILLER_67_220 VDD VSS sg13cmos5l_fill_2
XFILLER_68_743 VDD VSS sg13cmos5l_decap_4
X_4174_ _4212_/A _4172_/B _4127_/A _4173_/Y VDD VSS sg13cmos5l_a21o_1
XFILLER_55_437 VDD VSS sg13cmos5l_fill_2
XFILLER_83_768 VDD VSS sg13cmos5l_decap_8
X_6815_ _6816_/A _6815_/A _6815_/B VDD VSS sg13cmos5l_xnor2_1
X_6746_ _6997_/B _6901_/A _6741_/Y _6745_/Y VDD VSS sg13cmos5l_o21ai_1
X_6677_ _6723_/B _6677_/A _6677_/B _6742_/B VDD VSS sg13cmos5l_nand3_1
X_5628_ _5629_/B _5628_/A _5680_/A VDD VSS sg13cmos5l_xnor2_1
X_5559_ _5560_/B _5747_/A _5559_/B VDD VSS sg13cmos5l_xnor2_1
Xoutput871 bank_A_rdata[11] _4275_/A VDD VSS sg13cmos5l_buf_1
Xoutput882 bank_A_rdata[21] wire999/A VDD VSS sg13cmos5l_buf_1
XFILLER_59_721 VDD VSS sg13cmos5l_fill_1
Xoutput893 bank_A_rdata[31] output893/A VDD VSS sg13cmos5l_buf_1
X_7229_ _7230_/A _7331_/B _7244_/A VDD VSS sg13cmos5l_nor2_1
XFILLER_58_231 VDD VSS sg13cmos5l_fill_2
XFILLER_76_36 VDD VSS sg13cmos5l_decap_8
XFILLER_73_201 VDD VSS sg13cmos5l_fill_1
Xbank_B_sram.gen_ihp_256x32.u_sram_256x32_1240 bank_B_sram.gen_ihp_256x32.u_sram_256x32/A_BM[31]
+ VDD VSS sg13cmos5l_tiehi
XFILLER_86_584 VDD VSS sg13cmos5l_decap_8
XFILLER_46_459 VDD VSS sg13cmos5l_fill_2
XFILLER_62_908 VDD VSS sg13cmos5l_decap_8
XFILLER_74_735 VDD VSS sg13cmos5l_decap_4
XFILLER_73_256 VDD VSS sg13cmos5l_decap_4
XFILLER_73_278 VDD VSS sg13cmos5l_decap_8
XFILLER_82_790 VDD VSS sg13cmos5l_decap_8
XFILLER_41_120 VDD VSS sg13cmos5l_decap_4
XFILLER_41_131 VDD VSS sg13cmos5l_decap_8
XFILLER_42_632 VDD VSS sg13cmos5l_fill_2
XFILLER_41_153 VDD VSS sg13cmos5l_decap_8
XFILLER_41_197 VDD VSS sg13cmos5l_decap_8
XFILLER_41_61 VDD VSS sg13cmos5l_decap_8
Xwire965 wire965/X wire965/A VDD VSS sg13cmos5l_buf_2
XFILLER_38_905 VDD VSS sg13cmos5l_decap_8
XFILLER_38_916 VDD VSS sg13cmos5l_fill_2
XFILLER_49_275 VDD VSS sg13cmos5l_decap_8
XFILLER_64_223 VDD VSS sg13cmos5l_fill_2
XFILLER_65_735 VDD VSS sg13cmos5l_decap_8
XFILLER_65_757 VDD VSS sg13cmos5l_fill_1
XFILLER_65_768 VDD VSS sg13cmos5l_decap_8
XFILLER_80_705 VDD VSS sg13cmos5l_decap_8
XFILLER_64_289 VDD VSS sg13cmos5l_decap_8
X_4930_ _4931_/B _4930_/A1 _4930_/A2 _5178_/B1 _5188_/B2 VDD VSS sg13cmos5l_a22oi_1
X_4861_ _4862_/B _4988_/A _4861_/B VDD VSS sg13cmos5l_xnor2_1
X_6600_ _6601_/A _6600_/A _6764_/A VDD VSS sg13cmos5l_nand2_2
XANTENNA_16 input788/X VDD VSS sg13cmos5l_antennanp
XANTENNA_27 _7709_/D VDD VSS sg13cmos5l_antennanp
X_7580_ _7584_/B _7580_/A _7623_/B _7623_/C _7623_/A VDD VSS sg13cmos5l_nand4_1
X_4792_ _4793_/B _4792_/A VDD VSS sg13cmos5l_inv_1
X_6531_ _6532_/A _6882_/B _6882_/A VDD VSS sg13cmos5l_nand2_2
X_6462_ _6847_/A _6462_/A _6464_/B VDD VSS sg13cmos5l_nor2b_1
XFILLER_63_0 VDD VSS sg13cmos5l_fill_2
X_6393_ _6826_/A _6393_/A _7671_/Q VDD VSS sg13cmos5l_xnor2_1
X_5413_ _5477_/A _5349_/B _5349_/A _5412_/Y VDD VSS sg13cmos5l_a21o_1
X_5344_ _5345_/B _5344_/A _5408_/B VDD VSS sg13cmos5l_xor2_1
XFILLER_88_816 VDD VSS sg13cmos5l_fill_1
X_5275_ _5276_/B _5335_/A _5460_/B _5275_/C VDD VSS sg13cmos5l_nor3_1
X_7014_ _7014_/Y _7087_/A _7014_/B VDD VSS sg13cmos5l_nor2_1
X_4226_ _4286_/A _4226_/A _4226_/B VDD VSS sg13cmos5l_xnor2_1
XFILLER_87_337 VDD VSS sg13cmos5l_decap_4
X_4157_ _4194_/A _4207_/A _4157_/B VDD VSS sg13cmos5l_xnor2_1
XFILLER_56_746 VDD VSS sg13cmos5l_fill_1
XFILLER_71_716 VDD VSS sg13cmos5l_fill_2
X_4088_ _4120_/A _4172_/B _4056_/A _4087_/Y VDD VSS sg13cmos5l_a21o_1
XFILLER_83_565 VDD VSS sg13cmos5l_decap_8
XFILLER_70_204 VDD VSS sg13cmos5l_fill_1
X_6729_ _6752_/A _7105_/A _7108_/S _7105_/B VDD VSS sg13cmos5l_nand3_1
XFILLER_11_20 VDD VSS sg13cmos5l_fill_1
Xbank_A_sram.gen_ihp_256x32.u_sram_256x32_1050 bank_A_sram.gen_ihp_256x32.u_sram_256x32_1050/L_LO
+ VDD VSS sg13cmos5l_tielo
Xbank_A_sram.gen_ihp_256x32.u_sram_256x32_1061 bank_A_sram.gen_ihp_256x32.u_sram_256x32_1061/L_LO
+ VDD VSS sg13cmos5l_tielo
XFILLER_79_805 VDD VSS sg13cmos5l_decap_8
Xbank_A_sram.gen_ihp_256x32.u_sram_256x32_1072 bank_A_sram.gen_ihp_256x32.u_sram_256x32_1072/L_LO
+ VDD VSS sg13cmos5l_tielo
Xbank_A_sram.gen_ihp_256x32.u_sram_256x32_1083 bank_A_sram.gen_ihp_256x32.u_sram_256x32_1083/L_LO
+ VDD VSS sg13cmos5l_tielo
Xbank_A_sram.gen_ihp_256x32.u_sram_256x32_1094 bank_A_sram.gen_ihp_256x32.u_sram_256x32_1094/L_LO
+ VDD VSS sg13cmos5l_tielo
XFILLER_78_315 VDD VSS sg13cmos5l_fill_1
XFILLER_87_79 VDD VSS sg13cmos5l_fill_1
XFILLER_87_871 VDD VSS sg13cmos5l_decap_8
XFILLER_47_735 VDD VSS sg13cmos5l_decap_4
XFILLER_46_267 VDD VSS sg13cmos5l_decap_8
XFILLER_47_779 VDD VSS sg13cmos5l_fill_2
XFILLER_74_587 VDD VSS sg13cmos5l_decap_4
XFILLER_42_473 VDD VSS sg13cmos5l_decap_8
XFILLER_52_71 VDD VSS sg13cmos5l_fill_1
XFILLER_69_348 VDD VSS sg13cmos5l_decap_4
X_5060_ _5381_/A _5060_/A VDD VSS sg13cmos5l_buf_1
XFILLER_38_702 VDD VSS sg13cmos5l_fill_2
X_4011_ _4012_/B _4037_/A _4011_/B VDD VSS sg13cmos5l_xor2_1
XFILLER_84_329 VDD VSS sg13cmos5l_fill_1
XFILLER_38_779 VDD VSS sg13cmos5l_decap_8
XFILLER_65_565 VDD VSS sg13cmos5l_fill_1
XFILLER_65_576 VDD VSS sg13cmos5l_decap_8
X_5962_ _5962_/Y _5962_/A _5962_/B VDD VSS sg13cmos5l_nor2_1
X_7701_ _7701_/Q _7702_/CLK _7701_/D place751/X VDD VSS sg13cmos5l_dfrbpq_1
X_4913_ _7680_/D _4975_/B _4913_/B VDD VSS sg13cmos5l_xor2_1
X_5893_ _5893_/Y _5893_/A _5865_/A VDD VSS sg13cmos5l_nor2b_1
XFILLER_32_19 VDD VSS sg13cmos5l_fill_2
XFILLER_61_793 VDD VSS sg13cmos5l_decap_8
X_7632_ _7632_/Y _7728_/D _7632_/B VDD VSS sg13cmos5l_nand2b_2
X_4844_ _4845_/A _4844_/A _4844_/B VDD VSS sg13cmos5l_xor2_1
X_7563_ _7563_/Y _7563_/A1 _7513_/A _7368_/B VDD VSS sg13cmos5l_a21oi_1
X_4775_ _4838_/B _4775_/A _4775_/B VDD VSS sg13cmos5l_xor2_1
X_6514_ _6515_/B _6512_/B _7684_/Q VDD VSS sg13cmos5l_nand2b_1
X_7494_ _7495_/A _7494_/A1 _7589_/B _7453_/B VDD VSS sg13cmos5l_a21oi_1
X_6445_ _6447_/A _6445_/A _6851_/A VDD VSS sg13cmos5l_nand2_2
X_6376_ _6377_/B _6376_/A _7709_/Q _6499_/C VDD VSS sg13cmos5l_nand3_1
X_5327_ _5343_/A _5327_/A _5327_/B VDD VSS sg13cmos5l_xor2_1
XFILLER_87_123 VDD VSS sg13cmos5l_decap_8
XFILLER_69_871 VDD VSS sg13cmos5l_decap_8
XFILLER_76_819 VDD VSS sg13cmos5l_decap_8
XFILLER_113_11 VDD VSS sg13cmos5l_decap_8
XFILLER_68_381 VDD VSS sg13cmos5l_decap_8
X_5189_ _5196_/A _5630_/A _5189_/B VDD VSS sg13cmos5l_xnor2_1
X_4209_ _4210_/B _4266_/A _4209_/B VDD VSS sg13cmos5l_xnor2_1
XFILLER_84_863 VDD VSS sg13cmos5l_decap_8
XFILLER_44_716 VDD VSS sg13cmos5l_fill_1
XFILLER_56_587 VDD VSS sg13cmos5l_decap_8
XFILLER_83_384 VDD VSS sg13cmos5l_decap_8
XFILLER_43_259 VDD VSS sg13cmos5l_fill_1
XFILLER_71_557 VDD VSS sg13cmos5l_fill_2
XFILLER_40_900 VDD VSS sg13cmos5l_decap_8
XFILLER_79_646 VDD VSS sg13cmos5l_decap_8
XFILLER_66_318 VDD VSS sg13cmos5l_decap_8
XFILLER_66_329 VDD VSS sg13cmos5l_fill_2
XFILLER_75_863 VDD VSS sg13cmos5l_decap_8
XFILLER_62_557 VDD VSS sg13cmos5l_fill_2
XFILLER_62_579 VDD VSS sg13cmos5l_decap_8
XFILLER_42_270 VDD VSS sg13cmos5l_decap_8
X_4560_ _4571_/A _4560_/A _4560_/B VDD VSS sg13cmos5l_nor2_1
X_4491_ _4492_/B _4565_/B1 _4303_/A wire990/X _4800_/B2 VDD VSS sg13cmos5l_a22oi_1
X_6161_ _6161_/Y _6138_/B _6139_/B _6159_/Y VDD VSS sg13cmos5l_a21oi_1
Xhold2018 _6192_/A _7723_/Q VDD VSS sg13cmos5l_dlygate4sd3_1
X_5112_ _5172_/A _5171_/B _5302_/A VDD VSS sg13cmos5l_nand2_1
X_6092_ _6096_/A _6092_/A VDD VSS sg13cmos5l_inv_1
X_5043_ _5108_/B _5043_/A _5043_/B VDD VSS sg13cmos5l_nand2_1
XFILLER_78_690 VDD VSS sg13cmos5l_decap_8
XFILLER_27_19 VDD VSS sg13cmos5l_fill_2
XFILLER_38_543 VDD VSS sg13cmos5l_decap_8
XFILLER_66_852 VDD VSS sg13cmos5l_decap_8
XFILLER_38_598 VDD VSS sg13cmos5l_decap_8
XFILLER_65_362 VDD VSS sg13cmos5l_fill_2
XFILLER_81_833 VDD VSS sg13cmos5l_decap_8
XFILLER_80_310 VDD VSS sg13cmos5l_decap_4
XFILLER_65_395 VDD VSS sg13cmos5l_decap_4
X_6994_ _7233_/A _6994_/A _7178_/S VDD VSS sg13cmos5l_nand2_2
XFILLER_53_579 VDD VSS sg13cmos5l_decap_8
X_5945_ _5990_/A _5945_/A _5989_/A VDD VSS sg13cmos5l_xor2_1
XFILLER_80_354 VDD VSS sg13cmos5l_fill_2
X_5876_ _5876_/X _5876_/A _5876_/B VDD VSS sg13cmos5l_and2_1
XFILLER_80_398 VDD VSS sg13cmos5l_decap_8
X_7615_ _7616_/B _7615_/A _7615_/B _7615_/C _7615_/D VDD VSS sg13cmos5l_nand4_1
X_4827_ _4827_/Y _4827_/A _4827_/B VDD VSS sg13cmos5l_nor2_1
X_7546_ _7561_/A _7616_/C _7613_/A _7613_/B _7546_/D VDD VSS sg13cmos5l_nand4_1
X_4758_ _4775_/A _4758_/A _4758_/B VDD VSS sg13cmos5l_xor2_1
XFILLER_111_8 VDD VSS sg13cmos5l_decap_8
X_7477_ _7605_/B _7603_/A _7477_/B VDD VSS sg13cmos5l_xnor2_1
X_4689_ _4690_/B _5244_/B1 _4753_/A2 _5178_/B1 _4753_/B2 VDD VSS sg13cmos5l_a22oi_1
XFILLER_68_59 VDD VSS sg13cmos5l_decap_4
X_6359_ _6361_/A _6368_/C _6359_/B VDD VSS sg13cmos5l_xnor2_1
XFILLER_88_421 VDD VSS sg13cmos5l_decap_8
XFILLER_88_454 VDD VSS sg13cmos5l_decap_4
XFILLER_75_115 VDD VSS sg13cmos5l_fill_1
XFILLER_76_638 VDD VSS sg13cmos5l_fill_2
XFILLER_75_137 VDD VSS sg13cmos5l_fill_1
XFILLER_57_874 VDD VSS sg13cmos5l_decap_8
XFILLER_84_660 VDD VSS sg13cmos5l_decap_8
XFILLER_72_844 VDD VSS sg13cmos5l_decap_8
XFILLER_40_774 VDD VSS sg13cmos5l_decap_8
XFILLER_67_605 VDD VSS sg13cmos5l_decap_8
XFILLER_66_115 VDD VSS sg13cmos5l_fill_2
XFILLER_48_863 VDD VSS sg13cmos5l_decap_8
XFILLER_66_137 VDD VSS sg13cmos5l_decap_8
XFILLER_66_148 VDD VSS sg13cmos5l_decap_4
Xinput760 input760/X bank_A_addr[5] VDD VSS sg13cmos5l_buf_1
Xinput771 input771/X bank_A_wdata[17] VDD VSS sg13cmos5l_buf_1
Xinput782 input782/X bank_A_wdata[27] VDD VSS sg13cmos5l_buf_1
XFILLER_82_608 VDD VSS sg13cmos5l_decap_8
XFILLER_47_373 VDD VSS sg13cmos5l_decap_4
Xinput793 input793/X bank_A_wdata[8] VDD VSS sg13cmos5l_buf_1
XFILLER_62_310 VDD VSS sg13cmos5l_fill_2
XFILLER_63_833 VDD VSS sg13cmos5l_decap_8
X_5730_ _5736_/C _5731_/A _5731_/B _5731_/C VDD VSS sg13cmos5l_a21o_1
X_7400_ _7409_/B _7376_/A _7276_/X _7399_/Y VDD VSS sg13cmos5l_o21ai_1
X_5661_ _5662_/A _5598_/B _5598_/A _5660_/Y VDD VSS sg13cmos5l_a21o_1
X_5592_ _5654_/A _5592_/A _5592_/B VDD VSS sg13cmos5l_xnor2_1
X_4612_ _4612_/Y _4545_/A _4611_/Y _4547_/Y VDD VSS sg13cmos5l_o21ai_1
X_7331_ _7550_/A _7323_/A _7331_/B VDD VSS sg13cmos5l_nand2b_1
X_4543_ _4549_/A _4550_/A _4551_/A VDD VSS sg13cmos5l_xnor2_1
X_7262_ _7262_/X _7262_/A _7294_/B VDD VSS sg13cmos5l_and2_1
Xrebuffer1402 rebuffer1402/X rebuffer1403/X VDD VSS sg13cmos5l_buf_1
X_6213_ _6213_/Y _6223_/A _6213_/B VDD VSS sg13cmos5l_nand2_1
X_4474_ _4478_/A _4547_/B _4479_/C VDD VSS sg13cmos5l_nand2_1
Xrebuffer1435 rebuffer1435/X rebuffer1436/X VDD VSS sg13cmos5l_buf_1
Xrebuffer1424 _6260_/A _6244_/Y VDD VSS sg13cmos5l_buf_1
Xrebuffer1413 rebuffer1413/X rebuffer1414/X VDD VSS sg13cmos5l_buf_1
X_7193_ _7193_/Y _7071_/Y _7072_/Y _7162_/B VDD VSS sg13cmos5l_a21oi_1
Xfanout938 _5370_/B1 _4873_/B1 VDD VSS sg13cmos5l_buf_1
Xfanout949 _5985_/B1 _5801_/B1 VDD VSS sg13cmos5l_buf_1
Xrebuffer1457 _4250_/B _4232_/B VDD VSS sg13cmos5l_buf_1
Xrebuffer1446 rebuffer1446/X rebuffer1447/X VDD VSS sg13cmos5l_buf_1
X_6144_ _6144_/Y _6144_/A VDD VSS sg13cmos5l_inv_1
X_6075_ _6078_/A _6103_/B _6103_/A VDD VSS sg13cmos5l_xor2_1
XFILLER_85_413 VDD VSS sg13cmos5l_fill_2
XFILLER_39_841 VDD VSS sg13cmos5l_decap_8
XFILLER_57_137 VDD VSS sg13cmos5l_decap_8
X_5026_ _5026_/Y _4956_/A _5026_/B VDD VSS sg13cmos5l_nand2b_1
XFILLER_38_384 VDD VSS sg13cmos5l_fill_1
XFILLER_53_310 VDD VSS sg13cmos5l_decap_4
XFILLER_66_693 VDD VSS sg13cmos5l_decap_8
XFILLER_81_630 VDD VSS sg13cmos5l_decap_8
XFILLER_41_505 VDD VSS sg13cmos5l_fill_2
XFILLER_54_866 VDD VSS sg13cmos5l_decap_8
X_6977_ _6979_/C _6805_/Y _6977_/B VDD VSS sg13cmos5l_nand2b_1
XFILLER_110_12 VDD VSS sg13cmos5l_decap_8
XFILLER_41_527 VDD VSS sg13cmos5l_decap_8
XFILLER_53_398 VDD VSS sg13cmos5l_decap_4
X_5928_ _5928_/Y _5928_/A _5928_/B VDD VSS sg13cmos5l_nand2_1
X_5859_ _5908_/S _5909_/B1 _6082_/A2 _5859_/B1 _6082_/B2 VDD VSS sg13cmos5l_a22oi_1
X_7529_ _7613_/A _7529_/A _7529_/B VDD VSS sg13cmos5l_xor2_1
XFILLER_77_914 VDD VSS sg13cmos5l_decap_4
XFILLER_48_104 VDD VSS sg13cmos5l_fill_1
Xrebuffer1991 rebuffer1991/X rebuffer1992/X VDD VSS sg13cmos5l_buf_1
Xrebuffer1980 rebuffer1980/X rebuffer1981/X VDD VSS sg13cmos5l_buf_1
XFILLER_57_671 VDD VSS sg13cmos5l_fill_1
XFILLER_64_619 VDD VSS sg13cmos5l_fill_1
XFILLER_45_855 VDD VSS sg13cmos5l_decap_8
XFILLER_63_129 VDD VSS sg13cmos5l_decap_8
XFILLER_72_641 VDD VSS sg13cmos5l_decap_4
XFILLER_71_173 VDD VSS sg13cmos5l_fill_2
XFILLER_5_11 VDD VSS sg13cmos5l_decap_8
X_4190_ _4241_/A _4144_/A _4143_/Y _4189_/Y VDD VSS sg13cmos5l_a21oi_2
XFILLER_39_115 VDD VSS sg13cmos5l_decap_8
XFILLER_55_608 VDD VSS sg13cmos5l_fill_1
XFILLER_83_917 VDD VSS sg13cmos5l_fill_1
X_6900_ _7225_/A _6991_/B _6900_/B _7108_/S VDD VSS sg13cmos5l_nand3_1
Xplace630 _5460_/B _5335_/B VDD VSS sg13cmos5l_buf_1
Xplace641 _6136_/B _5705_/A VDD VSS sg13cmos5l_buf_1
X_6831_ _6831_/Y _6831_/A _7142_/B VDD VSS sg13cmos5l_nand2_1
XFILLER_50_313 VDD VSS sg13cmos5l_fill_1
XFILLER_51_825 VDD VSS sg13cmos5l_decap_8
XFILLER_62_184 VDD VSS sg13cmos5l_decap_8
Xplace652 _5385_/A1 _4888_/A VDD VSS sg13cmos5l_buf_1
Xplace663 _4814_/B1 _4583_/B1 VDD VSS sg13cmos5l_buf_1
Xplace674 _7141_/A _7711_/Q VDD VSS sg13cmos5l_buf_1
Xplace685 _6499_/C _7710_/Q VDD VSS sg13cmos5l_buf_1
Xplace696 _7112_/B _6951_/A VDD VSS sg13cmos5l_buf_1
X_6762_ _6762_/Y _7054_/B _7004_/B _6761_/Y VDD VSS sg13cmos5l_o21ai_1
X_3974_ _3977_/B _3972_/A _4565_/B1 _4447_/A VDD VSS sg13cmos5l_a21oi_1
XFILLER_93_0 VDD VSS sg13cmos5l_fill_1
X_6693_ _6780_/A _6716_/B _6716_/A VDD VSS sg13cmos5l_nand2_2
X_5713_ _5714_/B _5459_/A _3996_/Y _5395_/A _4017_/Y VDD VSS sg13cmos5l_a22oi_1
X_5644_ _5645_/B _5705_/A _3948_/Y _5459_/A _3979_/Y VDD VSS sg13cmos5l_a22oi_1
X_7314_ _7314_/Y _7312_/Y _7350_/A2 _7328_/B VDD VSS sg13cmos5l_a21oi_1
X_5575_ _5576_/B _5949_/B1 _5871_/A2 _5575_/B1 _5871_/B2 VDD VSS sg13cmos5l_a22oi_1
X_4526_ _4526_/Y _4526_/A _4526_/B VDD VSS sg13cmos5l_nor2_1
X_7245_ _7258_/A _7245_/A _7245_/B _7531_/B VDD VSS sg13cmos5l_nand3_1
X_4457_ _4457_/Y _4457_/A _4457_/B VDD VSS sg13cmos5l_nand2_1
Xrebuffer1243 _6381_/B1 rebuffer1263/X VDD VSS sg13cmos5l_buf_1
X_7176_ _7650_/B _7176_/A _7176_/B VDD VSS sg13cmos5l_nand2_1
XFILLER_58_424 VDD VSS sg13cmos5l_fill_1
Xrebuffer1254 _6440_/A _6264_/B VDD VSS sg13cmos5l_buf_1
Xrebuffer1265 rebuffer1265/X _6255_/A VDD VSS sg13cmos5l_buf_1
Xrebuffer1276 rebuffer1276/X rebuffer1277/X VDD VSS sg13cmos5l_buf_1
X_6127_ _6128_/B _6152_/B _6152_/A VDD VSS sg13cmos5l_xnor2_1
X_4388_ _4391_/A _3972_/A _4389_/A _5204_/B1 VDD VSS sg13cmos5l_a21oi_1
XFILLER_85_210 VDD VSS sg13cmos5l_fill_2
XFILLER_74_906 VDD VSS sg13cmos5l_decap_8
XFILLER_74_917 VDD VSS sg13cmos5l_fill_1
Xrebuffer1287 rebuffer1287/X rebuffer1288/X VDD VSS sg13cmos5l_buf_1
Xrebuffer1298 rebuffer1298/X rebuffer1299/X VDD VSS sg13cmos5l_buf_1
XFILLER_86_766 VDD VSS sg13cmos5l_decap_8
XFILLER_46_619 VDD VSS sg13cmos5l_decap_8
X_6058_ _6081_/S _6082_/B1 _6082_/A2 _6058_/B1 _6082_/B2 VDD VSS sg13cmos5l_a22oi_1
XFILLER_121_11 VDD VSS sg13cmos5l_decap_8
XFILLER_38_181 VDD VSS sg13cmos5l_decap_4
X_5009_ _5010_/B _4766_/A _5009_/A2 _4701_/A _5140_/B2 VDD VSS sg13cmos5l_a22oi_1
XFILLER_53_184 VDD VSS sg13cmos5l_fill_2
XFILLER_41_357 VDD VSS sg13cmos5l_fill_1
XFILLER_42_858 VDD VSS sg13cmos5l_decap_8
XFILLER_39_72 VDD VSS sg13cmos5l_fill_1
XFILLER_49_435 VDD VSS sg13cmos5l_decap_8
XFILLER_65_906 VDD VSS sg13cmos5l_decap_8
XFILLER_64_405 VDD VSS sg13cmos5l_fill_2
XFILLER_65_917 VDD VSS sg13cmos5l_fill_1
XFILLER_77_788 VDD VSS sg13cmos5l_decap_8
XFILLER_41_880 VDD VSS sg13cmos5l_decap_8
X_5360_ _5361_/B _5360_/A _5360_/B VDD VSS sg13cmos5l_nand2_2
X_5291_ _5294_/A _5303_/B _5303_/A VDD VSS sg13cmos5l_xor2_1
X_4311_ _4312_/B _4739_/B1 _4048_/A _4738_/A1 _4311_/B2 VDD VSS sg13cmos5l_a22oi_1
X_7030_ _7030_/Y _7162_/A _7030_/B _7162_/C VDD VSS sg13cmos5l_nand3_1
X_4242_ _4247_/A _4245_/B _4242_/B VDD VSS sg13cmos5l_nor2_1
XFILLER_67_232 VDD VSS sg13cmos5l_fill_1
X_4173_ _4173_/Y _4173_/A _4173_/B VDD VSS sg13cmos5l_nor2_1
XFILLER_55_405 VDD VSS sg13cmos5l_decap_4
XFILLER_56_917 VDD VSS sg13cmos5l_fill_1
XFILLER_67_276 VDD VSS sg13cmos5l_fill_1
XFILLER_83_747 VDD VSS sg13cmos5l_decap_8
X_6814_ _6962_/A _6814_/A _6814_/B VDD VSS sg13cmos5l_xnor2_1
XFILLER_51_688 VDD VSS sg13cmos5l_fill_1
X_6745_ _6745_/Y _6901_/B _6901_/A VDD VSS sg13cmos5l_nand2_1
X_6676_ _6742_/B _6676_/A _6676_/B VDD VSS sg13cmos5l_nand2_1
X_5627_ _5680_/A _5578_/B _5578_/A _5626_/X VDD VSS sg13cmos5l_a21oi_1
X_5558_ _5559_/B _5558_/A1 _5623_/A2 _5558_/B1 _5687_/B2 VDD VSS sg13cmos5l_a22oi_1
X_4509_ _4510_/B _4738_/A1 _4930_/A2 _4620_/B1 _4686_/B2 VDD VSS sg13cmos5l_a22oi_1
XFILLER_4_8 VDD VSS sg13cmos5l_decap_8
Xoutput861 act_out[0] _6214_/Y VDD VSS sg13cmos5l_buf_1
Xoutput872 bank_A_rdata[12] _4326_/A VDD VSS sg13cmos5l_buf_1
X_7228_ _7244_/A _7302_/A1 _7224_/Y _7227_/Y VDD VSS sg13cmos5l_o21ai_1
X_5489_ _5552_/A _5489_/A _5489_/B _5489_/C VDD VSS sg13cmos5l_nand3_1
Xoutput883 bank_A_rdata[22] _5322_/A1 VDD VSS sg13cmos5l_buf_1
Xoutput894 bank_A_rdata[3] _4156_/A1 VDD VSS sg13cmos5l_buf_1
XFILLER_58_210 VDD VSS sg13cmos5l_decap_8
XFILLER_59_755 VDD VSS sg13cmos5l_fill_2
X_7159_ _7159_/Y _7157_/Y _7301_/A2 _7059_/Y VDD VSS sg13cmos5l_a21oi_1
XFILLER_46_416 VDD VSS sg13cmos5l_fill_2
Xbank_B_sram.gen_ihp_256x32.u_sram_256x32_1230 bank_B_sram.gen_ihp_256x32.u_sram_256x32/A_BM[21]
+ VDD VSS sg13cmos5l_tiehi
Xbank_B_sram.gen_ihp_256x32.u_sram_256x32_1241 bank_B_sram.gen_ihp_256x32.u_sram_256x32/A_DLY
+ VDD VSS sg13cmos5l_tiehi
XFILLER_86_563 VDD VSS sg13cmos5l_decap_8
XFILLER_74_769 VDD VSS sg13cmos5l_fill_1
XFILLER_42_611 VDD VSS sg13cmos5l_decap_8
XFILLER_42_644 VDD VSS sg13cmos5l_fill_1
XFILLER_42_677 VDD VSS sg13cmos5l_decap_8
Xwire966 wire966/X wire966/A VDD VSS sg13cmos5l_buf_2
Xwire977 wire977/X wire977/A VDD VSS sg13cmos5l_buf_4
Xwire988 _5459_/A wire988/A VDD VSS sg13cmos5l_buf_2
Xwire999 _4888_/A wire999/A VDD VSS sg13cmos5l_buf_2
XFILLER_37_8 VDD VSS sg13cmos5l_fill_2
XFILLER_66_81 VDD VSS sg13cmos5l_decap_4
XFILLER_53_909 VDD VSS sg13cmos5l_decap_8
XFILLER_64_268 VDD VSS sg13cmos5l_fill_2
XFILLER_45_471 VDD VSS sg13cmos5l_decap_4
XFILLER_60_430 VDD VSS sg13cmos5l_fill_1
X_4860_ _4861_/B _5050_/B1 _5179_/A2 _4986_/B1 _5246_/B2 VDD VSS sg13cmos5l_a22oi_1
XFILLER_60_463 VDD VSS sg13cmos5l_fill_2
XANTENNA_17 input793/X VDD VSS sg13cmos5l_antennanp
XANTENNA_28 _7712_/D VDD VSS sg13cmos5l_antennanp
XFILLER_60_496 VDD VSS sg13cmos5l_fill_2
X_6530_ _6882_/A _6530_/A _6532_/B VDD VSS sg13cmos5l_nor2b_1
X_4791_ _4793_/A _4791_/A VDD VSS sg13cmos5l_inv_1
X_6461_ _6464_/B _6461_/A _7678_/Q _6461_/C VDD VSS sg13cmos5l_nand3_1
X_6392_ _6393_/A _6388_/Y _6401_/B _6450_/A2 VDD VSS sg13cmos5l_o21ai_1
X_5412_ _5412_/Y _5412_/A _5350_/B VDD VSS sg13cmos5l_nor2b_1
X_5343_ _5408_/B _5343_/A _5343_/B VDD VSS sg13cmos5l_xor2_1
X_5274_ _5275_/C _5274_/A VDD VSS sg13cmos5l_inv_1
XFILLER_88_839 VDD VSS sg13cmos5l_fill_1
X_7013_ _7013_/Y _7085_/B _6825_/Y _7012_/Y VDD VSS sg13cmos5l_o21ai_1
X_4225_ _4226_/B _4225_/A _4225_/B VDD VSS sg13cmos5l_xor2_1
X_4156_ _4157_/B _4156_/A1 _4048_/A _3964_/C _4311_/B2 VDD VSS sg13cmos5l_a22oi_1
XFILLER_83_511 VDD VSS sg13cmos5l_decap_8
XFILLER_55_257 VDD VSS sg13cmos5l_decap_8
X_4087_ _4087_/Y _4087_/A _4087_/B VDD VSS sg13cmos5l_nor2_1
XFILLER_83_555 VDD VSS sg13cmos5l_decap_8
XFILLER_71_739 VDD VSS sg13cmos5l_decap_8
Xclkbuf_4_1_0_clk_i_regs clkload0/A clkbuf_0_clk_i_regs/X VDD VSS sg13cmos5l_buf_8
XFILLER_64_791 VDD VSS sg13cmos5l_fill_2
X_4989_ _4992_/A _5049_/S _4989_/B VDD VSS sg13cmos5l_xnor2_1
X_6728_ _7105_/B _6728_/A _7054_/B VDD VSS sg13cmos5l_nand2_1
X_6659_ _6661_/B _7701_/Q _6659_/B VDD VSS sg13cmos5l_xnor2_1
Xbank_A_sram.gen_ihp_256x32.u_sram_256x32_1040 bank_A_sram.gen_ihp_256x32.u_sram_256x32_1040/L_LO
+ VDD VSS sg13cmos5l_tielo
Xbank_A_sram.gen_ihp_256x32.u_sram_256x32_1051 bank_A_sram.gen_ihp_256x32.u_sram_256x32_1051/L_LO
+ VDD VSS sg13cmos5l_tielo
Xbank_A_sram.gen_ihp_256x32.u_sram_256x32_1062 bank_A_sram.gen_ihp_256x32.u_sram_256x32_1062/L_LO
+ VDD VSS sg13cmos5l_tielo
Xbank_A_sram.gen_ihp_256x32.u_sram_256x32_1073 bank_A_sram.gen_ihp_256x32.u_sram_256x32_1073/L_LO
+ VDD VSS sg13cmos5l_tielo
Xbank_A_sram.gen_ihp_256x32.u_sram_256x32_1084 bank_A_sram.gen_ihp_256x32.u_sram_256x32_1084/L_LO
+ VDD VSS sg13cmos5l_tielo
Xbank_A_sram.gen_ihp_256x32.u_sram_256x32_1095 bank_A_sram.gen_ihp_256x32.u_sram_256x32_1095/L_LO
+ VDD VSS sg13cmos5l_tielo
XFILLER_87_850 VDD VSS sg13cmos5l_decap_8
XFILLER_74_522 VDD VSS sg13cmos5l_decap_4
XFILLER_61_216 VDD VSS sg13cmos5l_decap_4
XFILLER_62_728 VDD VSS sg13cmos5l_fill_2
XFILLER_74_599 VDD VSS sg13cmos5l_fill_1
XFILLER_42_441 VDD VSS sg13cmos5l_decap_4
XFILLER_52_94 VDD VSS sg13cmos5l_decap_8
XFILLER_28_4 VDD VSS sg13cmos5l_fill_1
X_4010_ _4011_/B _4010_/A _4034_/A VDD VSS sg13cmos5l_xor2_1
XFILLER_77_80 VDD VSS sg13cmos5l_fill_1
XFILLER_65_500 VDD VSS sg13cmos5l_fill_1
XFILLER_77_382 VDD VSS sg13cmos5l_decap_8
XFILLER_38_758 VDD VSS sg13cmos5l_decap_8
X_5961_ _5961_/Y _5961_/A VDD VSS sg13cmos5l_inv_1
X_7700_ _7700_/Q _7704_/CLK _7700_/D place753/X VDD VSS sg13cmos5l_dfrbpq_1
X_4912_ _4975_/A _4848_/B _4849_/A _4911_/Y VDD VSS sg13cmos5l_o21ai_1
XFILLER_80_536 VDD VSS sg13cmos5l_fill_1
X_7631_ _7632_/B _7608_/B _7631_/B VDD VSS sg13cmos5l_nand2b_2
X_5892_ _5967_/B _5892_/A _5882_/A VDD VSS sg13cmos5l_nor2b_1
X_4843_ _4844_/B _4843_/A _4850_/A VDD VSS sg13cmos5l_xnor2_1
X_7562_ _7565_/D _7562_/A _7618_/D _7618_/A _7562_/D VDD VSS sg13cmos5l_nand4_1
X_4774_ _4775_/B _4807_/A _4774_/B VDD VSS sg13cmos5l_xnor2_1
X_7493_ _7626_/A _7493_/A _7493_/B VDD VSS sg13cmos5l_xor2_1
X_6513_ _6515_/A _6513_/A _6880_/A VDD VSS sg13cmos5l_nand2_2
X_6444_ _6851_/A _7676_/Q _6444_/B VDD VSS sg13cmos5l_xnor2_1
X_6375_ _6383_/B _6375_/A _6375_/B VDD VSS sg13cmos5l_nand2_2
X_5326_ _5327_/B _5374_/A _5374_/B VDD VSS sg13cmos5l_xor2_1
XFILLER_87_102 VDD VSS sg13cmos5l_fill_2
XFILLER_69_850 VDD VSS sg13cmos5l_decap_8
X_4208_ _4209_/B _3964_/C _4378_/A2 _3965_/B _4378_/B2 VDD VSS sg13cmos5l_a22oi_1
XFILLER_87_157 VDD VSS sg13cmos5l_decap_8
X_5188_ _5189_/B _5493_/B1 _5380_/A2 _5430_/B1 _5188_/B2 VDD VSS sg13cmos5l_a22oi_1
XFILLER_87_179 VDD VSS sg13cmos5l_fill_2
X_4139_ _4140_/B _4139_/A _4139_/B VDD VSS sg13cmos5l_nand2_1
XFILLER_84_842 VDD VSS sg13cmos5l_decap_8
XFILLER_83_330 VDD VSS sg13cmos5l_decap_8
XFILLER_71_514 VDD VSS sg13cmos5l_fill_2
XFILLER_71_536 VDD VSS sg13cmos5l_decap_8
XFILLER_73_49 VDD VSS sg13cmos5l_decap_4
XFILLER_52_750 VDD VSS sg13cmos5l_fill_1
XFILLER_78_135 VDD VSS sg13cmos5l_fill_1
XFILLER_78_124 VDD VSS sg13cmos5l_fill_1
XFILLER_59_393 VDD VSS sg13cmos5l_fill_2
XFILLER_75_842 VDD VSS sg13cmos5l_decap_8
XFILLER_62_525 VDD VSS sg13cmos5l_fill_1
XFILLER_62_536 VDD VSS sg13cmos5l_fill_2
XFILLER_43_794 VDD VSS sg13cmos5l_decap_8
X_4490_ _4505_/A _5045_/A _4489_/B _4489_/Y VDD VSS sg13cmos5l_o21ai_1
X_6160_ _6160_/Y _6138_/B _6175_/B VDD VSS sg13cmos5l_nand2b_1
X_5111_ _5228_/A _5111_/A _5111_/B VDD VSS sg13cmos5l_nand2_1
Xhold2019 _6198_/A _7725_/Q VDD VSS sg13cmos5l_dlygate4sd3_1
X_6091_ _6092_/A _6124_/B _6124_/A VDD VSS sg13cmos5l_xor2_1
XFILLER_66_831 VDD VSS sg13cmos5l_decap_8
X_5042_ _5043_/B _5042_/A _5042_/B VDD VSS sg13cmos5l_nand2_1
XFILLER_85_639 VDD VSS sg13cmos5l_decap_8
XFILLER_38_566 VDD VSS sg13cmos5l_fill_2
XFILLER_65_374 VDD VSS sg13cmos5l_fill_2
XFILLER_81_812 VDD VSS sg13cmos5l_decap_8
XFILLER_80_333 VDD VSS sg13cmos5l_decap_4
XFILLER_80_322 VDD VSS sg13cmos5l_fill_1
X_5944_ _5989_/A _5944_/A _5944_/B VDD VSS sg13cmos5l_xnor2_1
XFILLER_81_889 VDD VSS sg13cmos5l_decap_8
X_5875_ _5878_/A _5907_/A VDD VSS sg13cmos5l_inv_1
XFILLER_80_388 VDD VSS sg13cmos5l_fill_2
X_7614_ _7615_/C _7614_/A _7614_/B VDD VSS sg13cmos5l_and2_1
X_4826_ _4827_/B _4947_/A _4947_/B _4826_/C VDD VSS sg13cmos5l_nor3_1
X_7545_ _7546_/D _7615_/B _7615_/D _7545_/C _7615_/A VDD VSS sg13cmos5l_nor4_1
X_4757_ _4758_/B _4803_/A _4803_/B VDD VSS sg13cmos5l_xor2_1
X_7476_ _7603_/B _7284_/Y _7397_/A _7399_/A VDD VSS sg13cmos5l_a21oi_1
X_6427_ _6483_/A _6611_/B _6611_/A VDD VSS sg13cmos5l_nor2_1
X_6358_ _6368_/C _6621_/A _6645_/B VDD VSS sg13cmos5l_nand2_1
XFILLER_68_27 VDD VSS sg13cmos5l_decap_8
XFILLER_88_411 VDD VSS sg13cmos5l_fill_2
X_6289_ _6602_/A _6323_/A VDD VSS sg13cmos5l_inv_2
XFILLER_76_617 VDD VSS sg13cmos5l_decap_8
XFILLER_88_499 VDD VSS sg13cmos5l_decap_8
XFILLER_56_330 VDD VSS sg13cmos5l_fill_2
XFILLER_57_853 VDD VSS sg13cmos5l_decap_8
XFILLER_17_20 VDD VSS sg13cmos5l_fill_1
XFILLER_56_363 VDD VSS sg13cmos5l_decap_8
XFILLER_72_823 VDD VSS sg13cmos5l_decap_8
XFILLER_71_322 VDD VSS sg13cmos5l_fill_1
XFILLER_83_193 VDD VSS sg13cmos5l_fill_2
XFILLER_71_388 VDD VSS sg13cmos5l_fill_2
XFILLER_58_82 VDD VSS sg13cmos5l_fill_1
XFILLER_67_628 VDD VSS sg13cmos5l_fill_1
XFILLER_79_499 VDD VSS sg13cmos5l_decap_8
XFILLER_47_330 VDD VSS sg13cmos5l_decap_8
XFILLER_48_842 VDD VSS sg13cmos5l_decap_8
Xinput761 input761/X bank_A_addr[6] VDD VSS sg13cmos5l_buf_1
Xinput772 input772/X bank_A_wdata[18] VDD VSS sg13cmos5l_buf_1
Xinput783 input783/X bank_A_wdata[28] VDD VSS sg13cmos5l_buf_1
XFILLER_63_812 VDD VSS sg13cmos5l_decap_8
Xinput794 input794/X bank_A_wdata[9] VDD VSS sg13cmos5l_buf_1
XFILLER_75_694 VDD VSS sg13cmos5l_decap_4
XFILLER_62_344 VDD VSS sg13cmos5l_fill_1
XFILLER_63_889 VDD VSS sg13cmos5l_decap_8
X_3990_ _4168_/A quant_cfg[5] VDD VSS sg13cmos5l_buf_1
XFILLER_50_528 VDD VSS sg13cmos5l_fill_1
X_5660_ _5660_/Y _5660_/A _5599_/B VDD VSS sg13cmos5l_nor2b_1
X_4611_ _4611_/Y _4611_/A VDD VSS sg13cmos5l_inv_1
X_5591_ _5592_/B _5650_/A _5650_/B VDD VSS sg13cmos5l_xor2_1
X_7330_ _7548_/A _7331_/B _7336_/A VDD VSS sg13cmos5l_xnor2_1
X_4542_ _4551_/A _4542_/A _4552_/A VDD VSS sg13cmos5l_xnor2_1
X_4473_ _4479_/C _4473_/A _4473_/B VDD VSS sg13cmos5l_nand2_1
Xrebuffer1425 _6808_/A2 _6279_/A VDD VSS sg13cmos5l_buf_1
Xrebuffer1414 rebuffer1414/X rebuffer1415/X VDD VSS sg13cmos5l_buf_1
Xrebuffer1403 rebuffer1403/X rebuffer1404/X VDD VSS sg13cmos5l_buf_1
X_7192_ _7192_/Y _7191_/B _7070_/Y _7191_/Y VDD VSS sg13cmos5l_o21ai_1
Xfanout939 _5430_/B1 _5066_/B1 VDD VSS sg13cmos5l_buf_1
Xrebuffer1447 rebuffer1447/X rebuffer1448/X VDD VSS sg13cmos5l_buf_1
Xrebuffer1436 rebuffer1436/X rebuffer1437/X VDD VSS sg13cmos5l_buf_1
X_6143_ _6147_/A _6143_/A _6143_/B VDD VSS sg13cmos5l_xor2_1
XFILLER_39_820 VDD VSS sg13cmos5l_decap_8
XFILLER_57_116 VDD VSS sg13cmos5l_decap_8
X_6074_ _6103_/A _5966_/A _6041_/B _6073_/Y VDD VSS sg13cmos5l_o21ai_1
XFILLER_38_330 VDD VSS sg13cmos5l_decap_8
XFILLER_57_127 VDD VSS sg13cmos5l_fill_1
X_5025_ _5025_/Y _5025_/A VDD VSS sg13cmos5l_inv_1
XFILLER_39_897 VDD VSS sg13cmos5l_decap_8
XFILLER_54_801 VDD VSS sg13cmos5l_fill_1
XFILLER_72_108 VDD VSS sg13cmos5l_decap_8
XFILLER_53_333 VDD VSS sg13cmos5l_decap_8
XFILLER_54_845 VDD VSS sg13cmos5l_decap_8
XFILLER_65_171 VDD VSS sg13cmos5l_fill_1
X_6976_ _6979_/A _6975_/Y _6976_/B VDD VSS sg13cmos5l_nand2b_1
X_5927_ _5931_/B _5927_/A _5927_/B VDD VSS sg13cmos5l_xnor2_1
XFILLER_81_686 VDD VSS sg13cmos5l_decap_8
XFILLER_80_163 VDD VSS sg13cmos5l_decap_8
XFILLER_119_11 VDD VSS sg13cmos5l_decap_8
X_5789_ _5789_/Y _5789_/A _5751_/A VDD VSS sg13cmos5l_nor2b_1
X_4809_ _4810_/B _5117_/B1 _4930_/A2 _5050_/B1 _5188_/B2 VDD VSS sg13cmos5l_a22oi_1
X_7528_ _7616_/C _7554_/B _7554_/A VDD VSS sg13cmos5l_xor2_1
X_7459_ _7460_/B _7234_/Y _7397_/A _7399_/A VDD VSS sg13cmos5l_a21o_1
Xrebuffer1981 rebuffer1981/X rebuffer1982/X VDD VSS sg13cmos5l_buf_1
Xrebuffer1970 rebuffer1970/X rebuffer1971/X VDD VSS sg13cmos5l_buf_1
XFILLER_88_285 VDD VSS sg13cmos5l_fill_1
XFILLER_76_425 VDD VSS sg13cmos5l_decap_8
Xrebuffer1992 rebuffer1992/X rebuffer1993/X VDD VSS sg13cmos5l_buf_1
XFILLER_76_436 VDD VSS sg13cmos5l_fill_2
XFILLER_63_108 VDD VSS sg13cmos5l_decap_8
XFILLER_76_469 VDD VSS sg13cmos5l_decap_8
XFILLER_44_300 VDD VSS sg13cmos5l_decap_8
XFILLER_44_311 VDD VSS sg13cmos5l_fill_2
XFILLER_45_834 VDD VSS sg13cmos5l_decap_8
XFILLER_72_620 VDD VSS sg13cmos5l_decap_8
XFILLER_71_141 VDD VSS sg13cmos5l_decap_8
XFILLER_71_152 VDD VSS sg13cmos5l_fill_1
XFILLER_44_84 VDD VSS sg13cmos5l_decap_8
XFILLER_68_915 VDD VSS sg13cmos5l_fill_2
XFILLER_79_285 VDD VSS sg13cmos5l_fill_1
XFILLER_48_683 VDD VSS sg13cmos5l_fill_2
XFILLER_82_428 VDD VSS sg13cmos5l_fill_2
XFILLER_51_804 VDD VSS sg13cmos5l_fill_2
XFILLER_62_141 VDD VSS sg13cmos5l_decap_8
Xplace620 _5586_/A _4176_/A VDD VSS sg13cmos5l_buf_1
Xplace631 _5335_/B _4172_/B VDD VSS sg13cmos5l_buf_1
X_6830_ _6831_/A _6825_/Y _7018_/B _6829_/Y VDD VSS sg13cmos5l_a21oi_1
XFILLER_62_163 VDD VSS sg13cmos5l_decap_8
Xclkbuf_4_6_0_clk_i_regs clkload3/A clkbuf_0_clk_i_regs/X VDD VSS sg13cmos5l_buf_8
Xplace642 _6114_/B _5459_/A VDD VSS sg13cmos5l_buf_1
Xplace653 _5558_/A1 _4825_/A VDD VSS sg13cmos5l_buf_1
Xplace664 _4755_/B1 _4520_/B1 VDD VSS sg13cmos5l_buf_1
X_6761_ _6761_/Y _7002_/A _7054_/B VDD VSS sg13cmos5l_nand2_1
XFILLER_50_336 VDD VSS sg13cmos5l_fill_1
Xplace675 _6407_/A _7711_/Q VDD VSS sg13cmos5l_buf_1
Xplace686 _7134_/B _7184_/B VDD VSS sg13cmos5l_buf_1
Xplace697 _6951_/A _6807_/A VDD VSS sg13cmos5l_buf_1
X_6692_ _6716_/A _7705_/Q _6692_/B VDD VSS sg13cmos5l_xnor2_1
X_5574_ _5626_/A _5870_/A _5574_/B VDD VSS sg13cmos5l_xnor2_1
X_4525_ _4526_/B _5335_/A _4525_/B _4525_/C VDD VSS sg13cmos5l_nor3_1
X_7244_ _7531_/B _7244_/A _7557_/A VDD VSS sg13cmos5l_nand2_1
X_4456_ _4456_/Y _4456_/A VDD VSS sg13cmos5l_inv_1
Xrebuffer1244 _6293_/B _6268_/Y VDD VSS sg13cmos5l_buf_8
X_7175_ _7177_/B _7719_/Q _7175_/B VDD VSS sg13cmos5l_xnor2_1
XFILLER_58_414 VDD VSS sg13cmos5l_fill_1
Xrebuffer1255 _7517_/B rebuffer1339/X VDD VSS sg13cmos5l_buf_1
Xrebuffer1266 _7537_/A _7203_/A VDD VSS sg13cmos5l_buf_1
Xrebuffer1277 rebuffer1277/X rebuffer1278/X VDD VSS sg13cmos5l_buf_1
X_6126_ _6152_/A _6135_/B _6135_/A VDD VSS sg13cmos5l_xor2_1
Xrebuffer1288 rebuffer1288/X rebuffer1289/X VDD VSS sg13cmos5l_buf_1
Xrebuffer1299 rebuffer1299/X rebuffer1300/X VDD VSS sg13cmos5l_buf_1
XFILLER_86_745 VDD VSS sg13cmos5l_decap_8
XFILLER_58_469 VDD VSS sg13cmos5l_decap_8
XFILLER_65_39 VDD VSS sg13cmos5l_decap_8
XFILLER_73_417 VDD VSS sg13cmos5l_fill_1
X_6057_ _6062_/A _6057_/A _6057_/B VDD VSS sg13cmos5l_nor2_1
XFILLER_38_160 VDD VSS sg13cmos5l_fill_1
X_5008_ _5058_/A _4953_/B _4953_/A _5007_/Y VDD VSS sg13cmos5l_a21oi_1
XFILLER_53_130 VDD VSS sg13cmos5l_fill_1
XFILLER_54_664 VDD VSS sg13cmos5l_fill_2
XFILLER_42_837 VDD VSS sg13cmos5l_decap_8
X_6959_ _6959_/Y _6956_/Y _7018_/B _6958_/Y VDD VSS sg13cmos5l_a21oi_1
Xmax_cap1009 _4446_/A _4762_/B1 VDD VSS sg13cmos5l_buf_2
XFILLER_39_51 VDD VSS sg13cmos5l_decap_8
XFILLER_77_767 VDD VSS sg13cmos5l_decap_8
XFILLER_55_50 VDD VSS sg13cmos5l_decap_8
XFILLER_55_83 VDD VSS sg13cmos5l_fill_2
XFILLER_60_612 VDD VSS sg13cmos5l_decap_8
XFILLER_60_623 VDD VSS sg13cmos5l_fill_2
X_5290_ _5303_/A _5290_/A _5290_/B VDD VSS sg13cmos5l_xor2_1
X_4241_ _4241_/Y _4241_/A _4188_/X VDD VSS sg13cmos5l_nor2b_2
XFILLER_87_509 VDD VSS sg13cmos5l_decap_8
XFILLER_68_701 VDD VSS sg13cmos5l_fill_2
X_4172_ _4173_/B _4172_/A _4172_/B _4172_/C VDD VSS sg13cmos5l_nor3_1
XFILLER_83_726 VDD VSS sg13cmos5l_decap_8
XFILLER_82_203 VDD VSS sg13cmos5l_decap_8
XFILLER_50_100 VDD VSS sg13cmos5l_decap_8
XFILLER_51_634 VDD VSS sg13cmos5l_decap_4
X_6813_ _7018_/A _6811_/Y _6960_/A _6955_/B VDD VSS sg13cmos5l_mux2_1
XFILLER_51_667 VDD VSS sg13cmos5l_decap_8
X_6744_ _6901_/B _6744_/A _6744_/B VDD VSS sg13cmos5l_xnor2_1
X_6675_ _6677_/B _6675_/A _6678_/B VDD VSS sg13cmos5l_nor2b_1
X_5626_ _5626_/X _5626_/A _5626_/B VDD VSS sg13cmos5l_and2_1
Xbank_A_sram.gen_ihp_256x32.u_sram_256x32_1200 bank_A_sram.gen_ihp_256x32.u_sram_256x32/A_BM[25]
+ VDD VSS sg13cmos5l_tiehi
X_5557_ _5621_/S _5557_/A1 _6136_/A _5557_/B1 _4496_/Y VDD VSS sg13cmos5l_a22oi_1
X_5488_ _7689_/D _5488_/A _5488_/B VDD VSS sg13cmos5l_xnor2_1
X_4508_ _4931_/A _4508_/A VDD VSS sg13cmos5l_buf_1
Xoutput862 act_out[1] _6216_/Y VDD VSS sg13cmos5l_buf_1
Xoutput873 bank_A_rdata[13] _4389_/A VDD VSS sg13cmos5l_buf_1
X_7227_ _7227_/Y _7141_/A _7226_/Y _7059_/A VDD VSS sg13cmos5l_o21ai_1
X_4439_ _4455_/A _4439_/A _4439_/B VDD VSS sg13cmos5l_xor2_1
Xoutput884 bank_A_rdata[23] wire997/A VDD VSS sg13cmos5l_buf_1
Xoutput895 bank_A_rdata[4] _4003_/A VDD VSS sg13cmos5l_buf_1
XFILLER_86_542 VDD VSS sg13cmos5l_fill_2
XFILLER_86_531 VDD VSS sg13cmos5l_decap_8
XFILLER_47_907 VDD VSS sg13cmos5l_decap_8
XFILLER_58_266 VDD VSS sg13cmos5l_decap_8
XFILLER_74_704 VDD VSS sg13cmos5l_fill_2
Xbank_B_sram.gen_ihp_256x32.u_sram_256x32_1220 bank_B_sram.gen_ihp_256x32.u_sram_256x32/A_BM[11]
+ VDD VSS sg13cmos5l_tiehi
Xbank_B_sram.gen_ihp_256x32.u_sram_256x32_1231 bank_B_sram.gen_ihp_256x32.u_sram_256x32/A_BM[22]
+ VDD VSS sg13cmos5l_tiehi
X_7089_ _7089_/Y _7112_/B _7187_/B VDD VSS sg13cmos5l_nor2_1
X_6109_ _6144_/A _6109_/A _6108_/Y VDD VSS sg13cmos5l_nor2b_1
XFILLER_58_277 VDD VSS sg13cmos5l_fill_1
Xbank_B_sram.gen_ihp_256x32.u_sram_256x32_1242 bank_B_sram.gen_ihp_256x32.u_sram_256x32/A_MEN
+ VDD VSS sg13cmos5l_tiehi
XFILLER_25_20 VDD VSS sg13cmos5l_fill_1
XFILLER_54_472 VDD VSS sg13cmos5l_fill_1
XFILLER_70_910 VDD VSS sg13cmos5l_decap_8
XFILLER_42_634 VDD VSS sg13cmos5l_fill_1
Xwire967 wire967/X wire967/A VDD VSS sg13cmos5l_buf_2
XFILLER_41_85 VDD VSS sg13cmos5l_decap_4
Xwire978 _4085_/A wire978/A VDD VSS sg13cmos5l_buf_8
Xwire989 wire989/X wire990/X VDD VSS sg13cmos5l_buf_2
XFILLER_77_542 VDD VSS sg13cmos5l_decap_4
XFILLER_77_564 VDD VSS sg13cmos5l_decap_8
XFILLER_37_428 VDD VSS sg13cmos5l_fill_2
XFILLER_49_288 VDD VSS sg13cmos5l_decap_8
XFILLER_49_299 VDD VSS sg13cmos5l_fill_2
XFILLER_64_225 VDD VSS sg13cmos5l_fill_1
XFILLER_77_597 VDD VSS sg13cmos5l_decap_4
XFILLER_72_280 VDD VSS sg13cmos5l_decap_8
X_4790_ _4844_/A _4790_/A _4784_/A VDD VSS sg13cmos5l_nor2b_1
XANTENNA_18 output909/A VDD VSS sg13cmos5l_antennanp
XANTENNA_29 _7718_/D VDD VSS sg13cmos5l_antennanp
X_6460_ _6462_/A _6461_/A _6461_/C _7678_/Q VDD VSS sg13cmos5l_a21oi_1
X_5411_ _5477_/B _5411_/A _5424_/B VDD VSS sg13cmos5l_xnor2_1
X_5342_ _5343_/B _5378_/A _5342_/B VDD VSS sg13cmos5l_xnor2_1
X_7012_ _7012_/Y _7012_/A _7085_/B VDD VSS sg13cmos5l_nand2_1
X_5273_ _5276_/A _5517_/A _5274_/A _5519_/B VDD VSS sg13cmos5l_a21oi_1
XFILLER_88_829 VDD VSS sg13cmos5l_fill_2
X_4224_ _4225_/B _4224_/A _4269_/A VDD VSS sg13cmos5l_xor2_1
XFILLER_55_214 VDD VSS sg13cmos5l_decap_4
XFILLER_56_737 VDD VSS sg13cmos5l_decap_4
XFILLER_68_597 VDD VSS sg13cmos5l_decap_8
X_4086_ _4087_/B _4172_/A _4086_/B _4086_/C VDD VSS sg13cmos5l_nor3_1
X_4988_ _4989_/B _4988_/A _4988_/B VDD VSS sg13cmos5l_xnor2_1
X_3939_ _3960_/A quant_cfg[1] VDD VSS sg13cmos5l_buf_1
X_6658_ _6659_/B _6655_/Y _6665_/B _6641_/C VDD VSS sg13cmos5l_o21ai_1
X_5609_ _5670_/A _5609_/A _5609_/B VDD VSS sg13cmos5l_and2_1
Xbank_A_sram.gen_ihp_256x32.u_sram_256x32_1030 bank_A_sram.gen_ihp_256x32.u_sram_256x32_1030/L_LO
+ VDD VSS sg13cmos5l_tielo
Xbank_A_sram.gen_ihp_256x32.u_sram_256x32_1041 bank_A_sram.gen_ihp_256x32.u_sram_256x32_1041/L_LO
+ VDD VSS sg13cmos5l_tielo
Xbank_A_sram.gen_ihp_256x32.u_sram_256x32_1052 bank_A_sram.gen_ihp_256x32.u_sram_256x32_1052/L_LO
+ VDD VSS sg13cmos5l_tielo
Xbank_A_sram.gen_ihp_256x32.u_sram_256x32_1063 bank_A_sram.gen_ihp_256x32.u_sram_256x32_1063/L_LO
+ VDD VSS sg13cmos5l_tielo
Xbank_A_sram.gen_ihp_256x32.u_sram_256x32_1074 bank_A_sram.gen_ihp_256x32.u_sram_256x32_1074/L_LO
+ VDD VSS sg13cmos5l_tielo
Xbank_A_sram.gen_ihp_256x32.u_sram_256x32_1085 bank_A_sram.gen_ihp_256x32.u_sram_256x32_1085/L_LO
+ VDD VSS sg13cmos5l_tielo
Xbank_A_sram.gen_ihp_256x32.u_sram_256x32_1096 bank_A_sram.gen_ihp_256x32.u_sram_256x32_1096/L_LO
+ VDD VSS sg13cmos5l_tielo
XFILLER_59_531 VDD VSS sg13cmos5l_fill_1
XFILLER_47_715 VDD VSS sg13cmos5l_decap_8
XFILLER_74_501 VDD VSS sg13cmos5l_decap_4
XFILLER_46_247 VDD VSS sg13cmos5l_fill_2
XFILLER_74_567 VDD VSS sg13cmos5l_fill_2
XFILLER_70_762 VDD VSS sg13cmos5l_decap_8
XFILLER_42_486 VDD VSS sg13cmos5l_decap_4
XFILLER_37_214 VDD VSS sg13cmos5l_fill_1
XFILLER_78_884 VDD VSS sg13cmos5l_decap_8
XFILLER_77_92 VDD VSS sg13cmos5l_decap_4
XFILLER_53_707 VDD VSS sg13cmos5l_fill_2
XFILLER_53_718 VDD VSS sg13cmos5l_fill_2
X_5960_ _5964_/A _5960_/A _5998_/A VDD VSS sg13cmos5l_xnor2_1
XFILLER_52_228 VDD VSS sg13cmos5l_fill_1
X_5891_ _5892_/A _5891_/A VDD VSS sg13cmos5l_inv_1
X_4911_ _4911_/Y _4844_/A _4846_/Y _4844_/B VDD VSS sg13cmos5l_o21ai_1
XFILLER_61_751 VDD VSS sg13cmos5l_decap_4
XFILLER_61_773 VDD VSS sg13cmos5l_fill_2
X_7630_ _7631_/B _7630_/A _7602_/A VDD VSS sg13cmos5l_nor2b_2
X_4842_ _4850_/A _4852_/A _4851_/A VDD VSS sg13cmos5l_xnor2_1
X_7561_ _7562_/A _7561_/A _7561_/B _7561_/C VDD VSS sg13cmos5l_nor3_1
X_4773_ _4774_/B _4773_/A _4773_/B VDD VSS sg13cmos5l_xor2_1
X_7492_ _7493_/B _7492_/A _7492_/B VDD VSS sg13cmos5l_nand2_1
X_6512_ _6880_/A _7684_/Q _6512_/B VDD VSS sg13cmos5l_xnor2_1
X_6443_ _6444_/B _6457_/A _6442_/Y _6450_/A2 VDD VSS sg13cmos5l_o21ai_1
X_6374_ _6375_/A _6815_/B _6815_/A VDD VSS sg13cmos5l_nand2_2
X_5325_ _5374_/B _5702_/A _5325_/B VDD VSS sg13cmos5l_xnor2_1
X_5256_ _5265_/A _5630_/A _5256_/B VDD VSS sg13cmos5l_xnor2_1
XFILLER_88_648 VDD VSS sg13cmos5l_decap_4
XFILLER_88_637 VDD VSS sg13cmos5l_decap_8
X_4207_ _4210_/A _4207_/A _4207_/B VDD VSS sg13cmos5l_xnor2_1
XFILLER_56_501 VDD VSS sg13cmos5l_fill_1
X_5187_ _5215_/A _5154_/B _5154_/A _5186_/Y VDD VSS sg13cmos5l_a21oi_1
XFILLER_84_821 VDD VSS sg13cmos5l_decap_8
XFILLER_56_545 VDD VSS sg13cmos5l_decap_8
X_4138_ _4140_/A _4138_/A _4138_/B VDD VSS sg13cmos5l_nand2_2
XFILLER_44_707 VDD VSS sg13cmos5l_decap_8
XFILLER_73_17 VDD VSS sg13cmos5l_fill_1
XFILLER_73_28 VDD VSS sg13cmos5l_decap_4
X_4069_ _4099_/A _4108_/C _4108_/B _4109_/B VDD VSS sg13cmos5l_a21oi_1
XFILLER_84_898 VDD VSS sg13cmos5l_decap_8
XFILLER_37_792 VDD VSS sg13cmos5l_fill_1
XFILLER_43_239 VDD VSS sg13cmos5l_decap_4
XFILLER_52_773 VDD VSS sg13cmos5l_decap_8
XFILLER_125_4 VDD VSS sg13cmos5l_decap_8
XFILLER_75_821 VDD VSS sg13cmos5l_decap_8
XFILLER_47_62 VDD VSS sg13cmos5l_decap_4
Xfanout193 _4854_/A _4556_/A VDD VSS sg13cmos5l_buf_1
XFILLER_86_180 VDD VSS sg13cmos5l_fill_2
XFILLER_47_567 VDD VSS sg13cmos5l_decap_8
XFILLER_47_84 VDD VSS sg13cmos5l_decap_4
XFILLER_75_898 VDD VSS sg13cmos5l_decap_8
XFILLER_62_559 VDD VSS sg13cmos5l_fill_1
XFILLER_43_773 VDD VSS sg13cmos5l_decap_8
XFILLER_63_83 VDD VSS sg13cmos5l_decap_4
XFILLER_8_12 VDD VSS sg13cmos5l_decap_8
X_6090_ _6124_/A _6120_/A _6090_/B VDD VSS sg13cmos5l_xnor2_1
X_5110_ _5111_/B _5110_/A _5110_/B VDD VSS sg13cmos5l_nand2_1
X_5041_ _5043_/A _5041_/A _5041_/B VDD VSS sg13cmos5l_nand2_1
XFILLER_85_618 VDD VSS sg13cmos5l_decap_8
XFILLER_66_810 VDD VSS sg13cmos5l_decap_8
XFILLER_65_331 VDD VSS sg13cmos5l_fill_2
XFILLER_84_139 VDD VSS sg13cmos5l_decap_4
XFILLER_65_353 VDD VSS sg13cmos5l_decap_4
XFILLER_65_364 VDD VSS sg13cmos5l_fill_1
XFILLER_66_887 VDD VSS sg13cmos5l_decap_8
X_6992_ _6994_/A _6992_/A VDD VSS sg13cmos5l_inv_1
X_5943_ _5944_/B _6136_/B _4158_/Y _6084_/B1 _4160_/Y VDD VSS sg13cmos5l_a22oi_1
XFILLER_81_868 VDD VSS sg13cmos5l_decap_8
X_5874_ _5907_/A _5874_/A _5874_/B VDD VSS sg13cmos5l_xor2_1
XFILLER_61_592 VDD VSS sg13cmos5l_fill_1
X_7613_ _7617_/B _7613_/A _7613_/B _7613_/C VDD VSS sg13cmos5l_nor3_1
X_4825_ _4826_/C _4825_/A VDD VSS sg13cmos5l_inv_1
X_7544_ _7615_/A _7544_/A _7544_/B VDD VSS sg13cmos5l_xor2_1
X_4756_ _4803_/B _5194_/A _4756_/B VDD VSS sg13cmos5l_xnor2_1
X_7475_ _7605_/A _7475_/A _7475_/B VDD VSS sg13cmos5l_nand2_2
X_4687_ _4694_/A _5060_/A _4687_/B VDD VSS sg13cmos5l_xnor2_1
X_6426_ _6436_/A _6821_/A _6820_/A _6821_/B VDD VSS sg13cmos5l_nand3_1
X_6357_ _6645_/B _6407_/A _6507_/A VDD VSS sg13cmos5l_nor2_1
X_5308_ _5317_/A _5546_/A _5307_/A _5307_/Y VDD VSS sg13cmos5l_a21oi_1
X_6288_ _6299_/A _6288_/A _6288_/B VDD VSS sg13cmos5l_nand2_2
XFILLER_69_681 VDD VSS sg13cmos5l_decap_8
X_5239_ _5303_/B _5239_/A _5239_/B VDD VSS sg13cmos5l_nand2_1
XFILLER_57_832 VDD VSS sg13cmos5l_decap_8
XFILLER_84_38 VDD VSS sg13cmos5l_fill_2
XFILLER_72_802 VDD VSS sg13cmos5l_decap_8
XFILLER_83_150 VDD VSS sg13cmos5l_fill_1
XFILLER_44_526 VDD VSS sg13cmos5l_decap_4
XFILLER_56_386 VDD VSS sg13cmos5l_fill_1
XFILLER_84_695 VDD VSS sg13cmos5l_decap_8
XFILLER_44_559 VDD VSS sg13cmos5l_decap_8
XFILLER_72_879 VDD VSS sg13cmos5l_decap_8
XFILLER_33_20 VDD VSS sg13cmos5l_fill_1
XFILLER_48_821 VDD VSS sg13cmos5l_decap_8
XFILLER_58_61 VDD VSS sg13cmos5l_fill_1
XFILLER_12_8 VDD VSS sg13cmos5l_decap_8
Xinput762 input762/X bank_A_addr[7] VDD VSS sg13cmos5l_buf_1
Xinput773 input773/X bank_A_wdata[19] VDD VSS sg13cmos5l_buf_1
Xinput784 input784/X bank_A_wdata[29] VDD VSS sg13cmos5l_buf_1
Xinput795 _3927_/A bank_A_we VDD VSS sg13cmos5l_buf_1
XFILLER_75_673 VDD VSS sg13cmos5l_decap_8
XFILLER_48_898 VDD VSS sg13cmos5l_decap_8
XFILLER_62_301 VDD VSS sg13cmos5l_fill_1
XFILLER_62_312 VDD VSS sg13cmos5l_fill_1
XFILLER_74_172 VDD VSS sg13cmos5l_decap_4
XFILLER_62_367 VDD VSS sg13cmos5l_fill_1
XFILLER_63_868 VDD VSS sg13cmos5l_decap_8
XFILLER_74_71 VDD VSS sg13cmos5l_fill_1
XFILLER_43_581 VDD VSS sg13cmos5l_decap_8
XFILLER_43_592 VDD VSS sg13cmos5l_fill_2
XFILLER_95_5 VDD VSS sg13cmos5l_fill_2
X_4610_ _4613_/A _4668_/B _4668_/A VDD VSS sg13cmos5l_xor2_1
X_5590_ _5650_/B _5590_/A _5590_/B VDD VSS sg13cmos5l_xnor2_1
X_4541_ _4552_/A _4553_/B _4553_/A VDD VSS sg13cmos5l_xor2_1
X_7260_ _7530_/B _7260_/A _7542_/B VDD VSS sg13cmos5l_nand2_2
X_4472_ _4547_/B _4545_/A _4469_/Y _4473_/A VDD VSS sg13cmos5l_a21o_1
X_7191_ _7191_/Y _7191_/A _7191_/B VDD VSS sg13cmos5l_nand2_1
X_6211_ _6211_/Y _6211_/A VDD VSS sg13cmos5l_inv_1
Xrebuffer1426 _6356_/A _6279_/A VDD VSS sg13cmos5l_buf_1
Xrebuffer1415 rebuffer1415/X rebuffer1416/X VDD VSS sg13cmos5l_buf_1
Xrebuffer1404 rebuffer1404/X rebuffer1405/X VDD VSS sg13cmos5l_buf_1
X_6142_ _6143_/B _6119_/B _6142_/B VDD VSS sg13cmos5l_nand2b_1
Xrebuffer1448 rebuffer1448/X rebuffer1449/X VDD VSS sg13cmos5l_buf_1
Xrebuffer1437 rebuffer1437/X rebuffer1438/X VDD VSS sg13cmos5l_buf_1
X_6073_ _6073_/Y _6073_/A _6073_/B VDD VSS sg13cmos5l_nand2_1
XFILLER_85_415 VDD VSS sg13cmos5l_fill_1
XFILLER_85_404 VDD VSS sg13cmos5l_fill_1
X_5024_ _5096_/B _5091_/A _5024_/B VDD VSS sg13cmos5l_xnor2_1
XFILLER_85_437 VDD VSS sg13cmos5l_fill_1
XFILLER_39_876 VDD VSS sg13cmos5l_decap_8
XFILLER_65_161 VDD VSS sg13cmos5l_fill_1
X_6975_ _6975_/Y _6957_/S _6798_/Y _6974_/Y VDD VSS sg13cmos5l_o21ai_1
XFILLER_81_665 VDD VSS sg13cmos5l_decap_8
X_5926_ _5927_/B _5967_/B _5967_/A VDD VSS sg13cmos5l_xnor2_1
XFILLER_80_186 VDD VSS sg13cmos5l_decap_4
X_5857_ _5866_/A _5796_/B _5547_/A _5857_/S VDD VSS sg13cmos5l_mux2_1
X_5788_ _5884_/A _5788_/A VDD VSS sg13cmos5l_buf_1
X_4808_ _4835_/A _4775_/B _4775_/A _4807_/Y VDD VSS sg13cmos5l_a21oi_1
X_7527_ _7554_/A _7558_/B _7559_/A _7305_/Y VDD VSS sg13cmos5l_a21o_1
X_4739_ _4740_/B _4800_/B1 _4303_/A _4739_/B1 _4800_/B2 VDD VSS sg13cmos5l_a22oi_1
X_7458_ _7594_/A _7458_/A _7491_/A _7492_/B VDD VSS sg13cmos5l_nand3_1
XFILLER_79_16 VDD VSS sg13cmos5l_fill_1
X_6409_ _6409_/Y _6410_/B _6410_/A VDD VSS sg13cmos5l_nor2_1
X_7389_ _7567_/B _7389_/A _7509_/A VDD VSS sg13cmos5l_nand2_2
Xrebuffer1982 rebuffer1982/X rebuffer1983/X VDD VSS sg13cmos5l_buf_1
Xrebuffer1971 rebuffer1971/X rebuffer1972/X VDD VSS sg13cmos5l_buf_1
Xrebuffer1960 rebuffer1960/X rebuffer1961/X VDD VSS sg13cmos5l_buf_1
XFILLER_48_139 VDD VSS sg13cmos5l_decap_8
Xrebuffer1993 rebuffer1993/X rebuffer1994/X VDD VSS sg13cmos5l_buf_1
XFILLER_45_813 VDD VSS sg13cmos5l_decap_8
XFILLER_56_172 VDD VSS sg13cmos5l_decap_4
XFILLER_84_481 VDD VSS sg13cmos5l_decap_4
XFILLER_71_120 VDD VSS sg13cmos5l_decap_8
XFILLER_72_687 VDD VSS sg13cmos5l_fill_2
XFILLER_44_63 VDD VSS sg13cmos5l_fill_2
XFILLER_71_186 VDD VSS sg13cmos5l_decap_4
XFILLER_60_62 VDD VSS sg13cmos5l_decap_8
XFILLER_60_95 VDD VSS sg13cmos5l_decap_8
XFILLER_69_93 VDD VSS sg13cmos5l_decap_8
XFILLER_83_908 VDD VSS sg13cmos5l_decap_8
XFILLER_47_161 VDD VSS sg13cmos5l_decap_8
XFILLER_48_673 VDD VSS sg13cmos5l_decap_4
XFILLER_63_654 VDD VSS sg13cmos5l_fill_1
Xplace610 _5514_/A2 _3996_/Y VDD VSS sg13cmos5l_buf_1
Xplace621 _5519_/B _3976_/B VDD VSS sg13cmos5l_buf_1
Xplace632 _4172_/B _4086_/B VDD VSS sg13cmos5l_buf_1
Xplace643 _3964_/C wire989/X VDD VSS sg13cmos5l_buf_2
Xplace654 _3965_/B _4162_/A1 VDD VSS sg13cmos5l_buf_1
Xplace665 _4497_/B1 wire1020/X VDD VSS sg13cmos5l_buf_1
X_6760_ _7002_/A _6915_/B _6916_/B _6759_/X VDD VSS sg13cmos5l_a21oi_1
XFILLER_44_890 VDD VSS sg13cmos5l_decap_8
Xplace676 _7296_/A _6981_/A VDD VSS sg13cmos5l_buf_1
Xplace687 _7191_/B _7006_/B VDD VSS sg13cmos5l_buf_1
Xplace698 _6807_/A _7709_/Q VDD VSS sg13cmos5l_buf_1
X_5711_ _5758_/A _5711_/A _5754_/B VDD VSS sg13cmos5l_nand2_1
X_3972_ _3977_/A _3972_/A _3972_/B VDD VSS sg13cmos5l_nor2_1
X_6691_ _6692_/B _6696_/A _6690_/Y _6641_/C VDD VSS sg13cmos5l_o21ai_1
X_5642_ _5647_/A _5810_/B _5642_/B VDD VSS sg13cmos5l_xnor2_1
X_5573_ _5574_/B _6026_/B1 _5869_/A2 _5985_/B1 _5869_/B2 VDD VSS sg13cmos5l_a22oi_1
X_7312_ _7312_/Y _7312_/A VDD VSS sg13cmos5l_inv_1
X_4524_ _4525_/C _4524_/A VDD VSS sg13cmos5l_inv_1
X_7243_ _7245_/B _7557_/A _7257_/A VDD VSS sg13cmos5l_xnor2_1
X_4455_ _4539_/B _4455_/A _4455_/B VDD VSS sg13cmos5l_xor2_1
XFILLER_59_905 VDD VSS sg13cmos5l_decap_8
X_7174_ _7175_/B _7159_/Y _7174_/B VDD VSS sg13cmos5l_nand2b_1
XFILLER_59_916 VDD VSS sg13cmos5l_fill_2
Xrebuffer1245 _6698_/B _6241_/A VDD VSS sg13cmos5l_buf_1
Xrebuffer1256 _7543_/A _7258_/A VDD VSS sg13cmos5l_buf_1
Xrebuffer1267 _7492_/A _7458_/A VDD VSS sg13cmos5l_buf_1
X_6125_ _6135_/A _6123_/Y _6120_/A _6124_/Y VDD VSS sg13cmos5l_o21ai_1
XFILLER_86_724 VDD VSS sg13cmos5l_decap_8
XFILLER_58_448 VDD VSS sg13cmos5l_decap_8
Xrebuffer1278 rebuffer1278/X rebuffer1279/X VDD VSS sg13cmos5l_buf_1
Xrebuffer1289 rebuffer1289/X _6255_/Y VDD VSS sg13cmos5l_buf_1
XFILLER_65_18 VDD VSS sg13cmos5l_decap_8
X_6056_ _6063_/A _6029_/B _5788_/A _6056_/S VDD VSS sg13cmos5l_mux2_1
XFILLER_85_267 VDD VSS sg13cmos5l_fill_1
X_5007_ _5007_/Y _5007_/A _5007_/B VDD VSS sg13cmos5l_nor2_1
XFILLER_42_816 VDD VSS sg13cmos5l_decap_8
XFILLER_53_142 VDD VSS sg13cmos5l_decap_4
XFILLER_53_186 VDD VSS sg13cmos5l_fill_1
X_6958_ _6958_/Y _7087_/A _6958_/B VDD VSS sg13cmos5l_nor2_1
XFILLER_81_28 VDD VSS sg13cmos5l_fill_2
X_6889_ _6890_/A _6877_/Y _7030_/B _6888_/Y VDD VSS sg13cmos5l_a21oi_2
X_5909_ _5948_/S _5949_/B1 _6082_/A2 _5909_/B1 _6082_/B2 VDD VSS sg13cmos5l_a22oi_1
XFILLER_39_30 VDD VSS sg13cmos5l_decap_8
XFILLER_77_702 VDD VSS sg13cmos5l_fill_2
XFILLER_77_757 VDD VSS sg13cmos5l_decap_4
XFILLER_76_201 VDD VSS sg13cmos5l_decap_8
XFILLER_64_429 VDD VSS sg13cmos5l_fill_2
XFILLER_55_73 VDD VSS sg13cmos5l_decap_4
XFILLER_44_197 VDD VSS sg13cmos5l_fill_2
XFILLER_60_657 VDD VSS sg13cmos5l_fill_2
X_4240_ _4245_/B _4350_/A _4238_/Y _4239_/Y VDD VSS sg13cmos5l_o21ai_1
X_4171_ _4172_/C _4171_/A VDD VSS sg13cmos5l_inv_1
XFILLER_83_705 VDD VSS sg13cmos5l_decap_8
XFILLER_55_418 VDD VSS sg13cmos5l_decap_4
XFILLER_51_613 VDD VSS sg13cmos5l_decap_8
X_6812_ _6960_/A _6812_/A _6812_/B VDD VSS sg13cmos5l_xnor2_1
XFILLER_50_123 VDD VSS sg13cmos5l_decap_8
XFILLER_51_657 VDD VSS sg13cmos5l_fill_1
XFILLER_50_156 VDD VSS sg13cmos5l_fill_1
X_6743_ _6744_/B _6743_/A _6743_/B VDD VSS sg13cmos5l_nand2_1
X_3955_ _4086_/B _3955_/A VDD VSS sg13cmos5l_inv_1
X_6674_ _6678_/B _6674_/A _7703_/Q _6684_/C VDD VSS sg13cmos5l_nand3_1
X_5625_ _5628_/A _5682_/S _5625_/B VDD VSS sg13cmos5l_xnor2_1
Xbank_A_sram.gen_ihp_256x32.u_sram_256x32_1201 bank_A_sram.gen_ihp_256x32.u_sram_256x32/A_BM[26]
+ VDD VSS sg13cmos5l_tiehi
X_5556_ _5564_/A _5496_/B _5302_/A _5556_/S VDD VSS sg13cmos5l_mux2_1
X_5487_ _5488_/B _5487_/A _5489_/B VDD VSS sg13cmos5l_nand2_1
X_4507_ _4537_/A _4455_/B _4455_/A _4506_/Y VDD VSS sg13cmos5l_a21oi_1
Xoutput863 act_out[2] _6218_/Y VDD VSS sg13cmos5l_buf_1
X_7226_ _7226_/Y _7226_/A _7234_/B VDD VSS sg13cmos5l_nand2_1
X_4438_ _4439_/B _4500_/A _4500_/B VDD VSS sg13cmos5l_xor2_1
Xoutput874 bank_A_rdata[14] _4446_/A VDD VSS sg13cmos5l_buf_1
Xoutput885 bank_A_rdata[24] wire996/A VDD VSS sg13cmos5l_buf_1
Xoutput896 bank_A_rdata[5] _4023_/A VDD VSS sg13cmos5l_buf_1
XFILLER_59_735 VDD VSS sg13cmos5l_fill_2
X_7157_ _7157_/Y _7152_/Y _7109_/A _7156_/Y VDD VSS sg13cmos5l_a21oi_1
X_4369_ _4369_/X _4369_/A _4369_/B VDD VSS sg13cmos5l_and2_1
XFILLER_86_510 VDD VSS sg13cmos5l_decap_8
XFILLER_58_245 VDD VSS sg13cmos5l_fill_1
Xbank_B_sram.gen_ihp_256x32.u_sram_256x32_1210 bank_B_sram.gen_ihp_256x32.u_sram_256x32/A_BM[1]
+ VDD VSS sg13cmos5l_tiehi
Xbank_B_sram.gen_ihp_256x32.u_sram_256x32_1221 bank_B_sram.gen_ihp_256x32.u_sram_256x32/A_BM[12]
+ VDD VSS sg13cmos5l_tiehi
X_7088_ _7187_/B _6958_/B _7087_/A _7087_/Y VDD VSS sg13cmos5l_a21oi_1
X_6108_ _6108_/Y _6088_/B _6108_/B VDD VSS sg13cmos5l_nand2b_1
XFILLER_74_749 VDD VSS sg13cmos5l_fill_1
Xbank_B_sram.gen_ihp_256x32.u_sram_256x32_1232 bank_B_sram.gen_ihp_256x32.u_sram_256x32/A_BM[23]
+ VDD VSS sg13cmos5l_tiehi
X_6039_ _6073_/B _6039_/A _6048_/A VDD VSS sg13cmos5l_xnor2_1
XFILLER_86_598 VDD VSS sg13cmos5l_decap_8
XFILLER_39_481 VDD VSS sg13cmos5l_decap_4
XFILLER_41_112 VDD VSS sg13cmos5l_decap_4
XFILLER_41_31 VDD VSS sg13cmos5l_fill_1
Xwire968 wire968/X wire968/A VDD VSS sg13cmos5l_buf_2
Xwire979 _4056_/A wire980/X VDD VSS sg13cmos5l_buf_8
XFILLER_49_223 VDD VSS sg13cmos5l_decap_8
XFILLER_49_256 VDD VSS sg13cmos5l_decap_4
XFILLER_65_749 VDD VSS sg13cmos5l_fill_2
XFILLER_61_900 VDD VSS sg13cmos5l_decap_8
XFILLER_80_719 VDD VSS sg13cmos5l_decap_8
XFILLER_60_465 VDD VSS sg13cmos5l_fill_1
XFILLER_82_93 VDD VSS sg13cmos5l_fill_2
XFILLER_82_71 VDD VSS sg13cmos5l_fill_2
XANTENNA_19 output911/A VDD VSS sg13cmos5l_antennanp
XFILLER_70_4 VDD VSS sg13cmos5l_fill_2
X_6390_ _6401_/B _6400_/A VDD VSS sg13cmos5l_inv_1
X_5410_ _5424_/B _5425_/B _5425_/A VDD VSS sg13cmos5l_xor2_1
X_5341_ _5342_/B _5341_/A _5341_/B VDD VSS sg13cmos5l_xor2_1
X_4223_ _4224_/A _4532_/A _4223_/B VDD VSS sg13cmos5l_xnor2_1
X_4154_ _4185_/B _5944_/A _4153_/B _4153_/Y VDD VSS sg13cmos5l_o21ai_1
XFILLER_56_727 VDD VSS sg13cmos5l_fill_2
XFILLER_68_576 VDD VSS sg13cmos5l_fill_2
X_4085_ _4086_/C _4085_/A VDD VSS sg13cmos5l_inv_1
XFILLER_83_579 VDD VSS sg13cmos5l_decap_8
XFILLER_51_465 VDD VSS sg13cmos5l_fill_1
X_6726_ _6728_/A _6726_/A VDD VSS sg13cmos5l_inv_1
X_4987_ _4988_/B _5178_/B1 _5179_/A2 _5117_/B1 _5246_/B2 VDD VSS sg13cmos5l_a22oi_1
X_3938_ _3953_/A _3964_/A _3965_/B VDD VSS sg13cmos5l_nand2_1
X_6657_ _6665_/B _6664_/A VDD VSS sg13cmos5l_inv_1
X_6588_ _6588_/Y _6588_/A _6587_/A VDD VSS sg13cmos5l_nor2b_1
X_5608_ _5609_/B _5608_/A _5608_/B _5608_/C VDD VSS sg13cmos5l_nand3_1
X_5539_ _5608_/B _5541_/B _5541_/A VDD VSS sg13cmos5l_nor2_1
Xbank_A_sram.gen_ihp_256x32.u_sram_256x32_1031 bank_A_sram.gen_ihp_256x32.u_sram_256x32_1031/L_LO
+ VDD VSS sg13cmos5l_tielo
Xbank_A_sram.gen_ihp_256x32.u_sram_256x32_1042 bank_A_sram.gen_ihp_256x32.u_sram_256x32_1042/L_LO
+ VDD VSS sg13cmos5l_tielo
Xbank_A_sram.gen_ihp_256x32.u_sram_256x32_1053 bank_A_sram.gen_ihp_256x32.u_sram_256x32_1053/L_LO
+ VDD VSS sg13cmos5l_tielo
Xbank_A_sram.gen_ihp_256x32.u_sram_256x32_1064 bank_A_sram.gen_ihp_256x32.u_sram_256x32_1064/L_LO
+ VDD VSS sg13cmos5l_tielo
Xbank_A_sram.gen_ihp_256x32.u_sram_256x32_1075 bank_A_sram.gen_ihp_256x32.u_sram_256x32_1075/L_LO
+ VDD VSS sg13cmos5l_tielo
Xbank_A_sram.gen_ihp_256x32.u_sram_256x32_1086 bank_A_sram.gen_ihp_256x32.u_sram_256x32_1086/L_LO
+ VDD VSS sg13cmos5l_tielo
XFILLER_79_819 VDD VSS sg13cmos5l_decap_8
Xbank_A_sram.gen_ihp_256x32.u_sram_256x32_1097 bank_A_sram.gen_ihp_256x32.u_sram_256x32_1097/L_LO
+ VDD VSS sg13cmos5l_tielo
X_7209_ _7209_/Y _7299_/A1 _7362_/B _7208_/Y VDD VSS sg13cmos5l_o21ai_1
XFILLER_59_587 VDD VSS sg13cmos5l_decap_4
XFILLER_87_885 VDD VSS sg13cmos5l_decap_8
XFILLER_86_373 VDD VSS sg13cmos5l_fill_1
XFILLER_86_351 VDD VSS sg13cmos5l_fill_1
XFILLER_46_226 VDD VSS sg13cmos5l_fill_1
XFILLER_74_546 VDD VSS sg13cmos5l_decap_8
XFILLER_69_329 VDD VSS sg13cmos5l_fill_2
XFILLER_78_863 VDD VSS sg13cmos5l_decap_8
XFILLER_38_738 VDD VSS sg13cmos5l_fill_2
XFILLER_38_749 VDD VSS sg13cmos5l_decap_4
XFILLER_46_760 VDD VSS sg13cmos5l_fill_1
XFILLER_52_207 VDD VSS sg13cmos5l_decap_8
XFILLER_45_281 VDD VSS sg13cmos5l_fill_1
XFILLER_73_590 VDD VSS sg13cmos5l_fill_2
X_5890_ _7696_/D _5890_/A _5934_/A VDD VSS sg13cmos5l_nor2b_1
X_4910_ _4975_/B _4974_/B _4974_/A VDD VSS sg13cmos5l_xor2_1
XFILLER_61_741 VDD VSS sg13cmos5l_decap_4
X_4841_ _4851_/A _4905_/A _4841_/B VDD VSS sg13cmos5l_xnor2_1
XFILLER_60_273 VDD VSS sg13cmos5l_fill_2
XFILLER_60_295 VDD VSS sg13cmos5l_decap_8
X_7560_ _7561_/C _7613_/C _7560_/B _7616_/A VDD VSS sg13cmos5l_nand3_1
X_4772_ _4773_/B _4818_/A _4818_/B VDD VSS sg13cmos5l_xor2_1
X_7491_ _7493_/A _7491_/A _7594_/B VDD VSS sg13cmos5l_nand2_1
X_6511_ _6512_/B _6519_/A _6510_/X _6502_/C VDD VSS sg13cmos5l_o21ai_1
X_6442_ _6442_/Y _6442_/A _6441_/A VDD VSS sg13cmos5l_nor2b_1
X_6373_ _6815_/A _6373_/A _6375_/B VDD VSS sg13cmos5l_nor2b_1
X_5324_ _5325_/B _5745_/B1 _5385_/A2 _5684_/B1 _5385_/B2 VDD VSS sg13cmos5l_a22oi_1
X_5255_ _5256_/B _5557_/B1 _5380_/A2 _5493_/B1 _6021_/B2 VDD VSS sg13cmos5l_a22oi_1
X_4206_ _4207_/B _4620_/B1 _4048_/A _4565_/B1 _4311_/B2 VDD VSS sg13cmos5l_a22oi_1
XFILLER_68_362 VDD VSS sg13cmos5l_decap_4
XFILLER_69_885 VDD VSS sg13cmos5l_decap_8
X_5186_ _5186_/Y _5186_/A _5153_/B VDD VSS sg13cmos5l_nor2b_1
XFILLER_84_800 VDD VSS sg13cmos5l_decap_8
X_4137_ _4146_/B _4147_/A _4148_/A VDD VSS sg13cmos5l_xor2_1
X_4068_ _4109_/B _4068_/A _4068_/B VDD VSS sg13cmos5l_nor2_1
XFILLER_84_877 VDD VSS sg13cmos5l_decap_8
XFILLER_83_354 VDD VSS sg13cmos5l_fill_2
XFILLER_51_240 VDD VSS sg13cmos5l_decap_8
XFILLER_40_914 VDD VSS sg13cmos5l_decap_4
X_7689_ _7689_/Q clkload9/A _7689_/D place754/X VDD VSS sg13cmos5l_dfrbpq_1
X_6709_ _6713_/B _6780_/A _6780_/B _6779_/B VDD VSS sg13cmos5l_nand3_1
XFILLER_87_682 VDD VSS sg13cmos5l_decap_8
XFILLER_75_800 VDD VSS sg13cmos5l_decap_8
XFILLER_59_384 VDD VSS sg13cmos5l_fill_1
XFILLER_59_395 VDD VSS sg13cmos5l_fill_1
XFILLER_75_877 VDD VSS sg13cmos5l_decap_8
XFILLER_74_376 VDD VSS sg13cmos5l_decap_8
XFILLER_69_159 VDD VSS sg13cmos5l_fill_1
X_5040_ _5101_/A _5040_/A _5040_/B VDD VSS sg13cmos5l_and2_1
XFILLER_38_513 VDD VSS sg13cmos5l_decap_8
XFILLER_38_524 VDD VSS sg13cmos5l_fill_2
XFILLER_65_310 VDD VSS sg13cmos5l_fill_1
XFILLER_84_129 VDD VSS sg13cmos5l_fill_2
XFILLER_77_181 VDD VSS sg13cmos5l_decap_4
XFILLER_38_557 VDD VSS sg13cmos5l_decap_4
XFILLER_38_568 VDD VSS sg13cmos5l_fill_1
XFILLER_66_866 VDD VSS sg13cmos5l_decap_8
X_6991_ _6992_/A _6991_/A _6991_/B VDD VSS sg13cmos5l_nand2_1
X_5942_ _5946_/A _5982_/A _5942_/B VDD VSS sg13cmos5l_xnor2_1
XFILLER_81_847 VDD VSS sg13cmos5l_decap_8
XFILLER_80_302 VDD VSS sg13cmos5l_decap_4
X_5873_ _5874_/B _5913_/A _5913_/B VDD VSS sg13cmos5l_xor2_1
X_7612_ _7634_/A _7657_/A _7612_/B VDD VSS sg13cmos5l_nand2_2
X_4824_ _4827_/A _5012_/A1 _4825_/A _5012_/B1 VDD VSS sg13cmos5l_a21oi_1
X_7543_ _7544_/B _7543_/A _7543_/B VDD VSS sg13cmos5l_nand2_1
X_4755_ _4756_/B _4814_/B1 _4878_/A2 _4755_/B1 _4878_/B2 VDD VSS sg13cmos5l_a22oi_1
X_7474_ _7475_/A _7594_/A _7595_/A _7594_/B _7597_/B VDD VSS sg13cmos5l_nand4_1
X_4686_ _4687_/B _4686_/A1 _4930_/A2 _4800_/B1 _4686_/B2 VDD VSS sg13cmos5l_a22oi_1
X_6425_ _6821_/B _6413_/B _7673_/Q VDD VSS sg13cmos5l_nand2b_1
Xbank_A_sram.gen_ihp_256x32.u_sram_256x32 input770/X input769/X bank_A_sram.gen_ihp_256x32.u_sram_256x32_1078/L_LO
+ bank_A_sram.gen_ihp_256x32.u_sram_256x32_1077/L_LO bank_A_sram.gen_ihp_256x32.u_sram_256x32/A_BM[16]
+ bank_A_sram.gen_ihp_256x32.u_sram_256x32/A_BM[15] bank_A_sram.gen_ihp_256x32.u_sram_256x32_1045/L_LO
+ bank_A_sram.gen_ihp_256x32.u_sram_256x32_1044/L_LO wire1006/A wire1008/A VSS VDD
+ VDD input771/X input768/X bank_A_sram.gen_ihp_256x32.u_sram_256x32_1079/L_LO bank_A_sram.gen_ihp_256x32.u_sram_256x32_1076/L_LO
+ bank_A_sram.gen_ihp_256x32.u_sram_256x32/A_BM[17] bank_A_sram.gen_ihp_256x32.u_sram_256x32/A_BM[14]
+ bank_A_sram.gen_ihp_256x32.u_sram_256x32_1046/L_LO bank_A_sram.gen_ihp_256x32.u_sram_256x32_1043/L_LO
+ wire1005/A wire1010/A input772/X input767/X bank_A_sram.gen_ihp_256x32.u_sram_256x32_1080/L_LO
+ bank_A_sram.gen_ihp_256x32.u_sram_256x32_1075/L_LO bank_A_sram.gen_ihp_256x32.u_sram_256x32/A_BM[18]
+ bank_A_sram.gen_ihp_256x32.u_sram_256x32/A_BM[13] bank_A_sram.gen_ihp_256x32.u_sram_256x32_1047/L_LO
+ bank_A_sram.gen_ihp_256x32.u_sram_256x32_1042/L_LO wire1004/A wire1012/A input773/X
+ input766/X bank_A_sram.gen_ihp_256x32.u_sram_256x32_1081/L_LO bank_A_sram.gen_ihp_256x32.u_sram_256x32_1074/L_LO
+ bank_A_sram.gen_ihp_256x32.u_sram_256x32/A_BM[19] bank_A_sram.gen_ihp_256x32.u_sram_256x32/A_BM[12]
+ bank_A_sram.gen_ihp_256x32.u_sram_256x32_1048/L_LO bank_A_sram.gen_ihp_256x32.u_sram_256x32_1041/L_LO
+ wire1003/A wire1014/A input775/X input765/X bank_A_sram.gen_ihp_256x32.u_sram_256x32_1082/L_LO
+ bank_A_sram.gen_ihp_256x32.u_sram_256x32_1073/L_LO bank_A_sram.gen_ihp_256x32.u_sram_256x32/A_BM[20]
+ bank_A_sram.gen_ihp_256x32.u_sram_256x32/A_BM[11] bank_A_sram.gen_ihp_256x32.u_sram_256x32_1049/L_LO
+ bank_A_sram.gen_ihp_256x32.u_sram_256x32_1040/L_LO wire1000/A wire1016/A input776/X
+ input764/X bank_A_sram.gen_ihp_256x32.u_sram_256x32_1083/L_LO bank_A_sram.gen_ihp_256x32.u_sram_256x32_1072/L_LO
+ bank_A_sram.gen_ihp_256x32.u_sram_256x32/A_BM[21] bank_A_sram.gen_ihp_256x32.u_sram_256x32/A_BM[10]
+ bank_A_sram.gen_ihp_256x32.u_sram_256x32_1050/L_LO bank_A_sram.gen_ihp_256x32.u_sram_256x32_1039/L_LO
+ wire999/A wire1018/A input777/X input794/X bank_A_sram.gen_ihp_256x32.u_sram_256x32_1084/L_LO
+ bank_A_sram.gen_ihp_256x32.u_sram_256x32_1071/L_LO bank_A_sram.gen_ihp_256x32.u_sram_256x32/A_BM[22]
+ bank_A_sram.gen_ihp_256x32.u_sram_256x32/A_BM[9] bank_A_sram.gen_ihp_256x32.u_sram_256x32_1051/L_LO
+ bank_A_sram.gen_ihp_256x32.u_sram_256x32_1038/L_LO _5322_/A1 wire975/A input778/X
+ input793/X bank_A_sram.gen_ihp_256x32.u_sram_256x32_1085/L_LO bank_A_sram.gen_ihp_256x32.u_sram_256x32_1070/L_LO
+ bank_A_sram.gen_ihp_256x32.u_sram_256x32/A_BM[23] bank_A_sram.gen_ihp_256x32.u_sram_256x32/A_BM[8]
+ bank_A_sram.gen_ihp_256x32.u_sram_256x32_1052/L_LO bank_A_sram.gen_ihp_256x32.u_sram_256x32_1037/L_LO
+ wire997/A wire977/A input779/X input792/X bank_A_sram.gen_ihp_256x32.u_sram_256x32_1086/L_LO
+ bank_A_sram.gen_ihp_256x32.u_sram_256x32_1069/L_LO bank_A_sram.gen_ihp_256x32.u_sram_256x32/A_BM[24]
+ bank_A_sram.gen_ihp_256x32.u_sram_256x32/A_BM[7] bank_A_sram.gen_ihp_256x32.u_sram_256x32_1053/L_LO
+ bank_A_sram.gen_ihp_256x32.u_sram_256x32_1036/L_LO wire996/A wire978/A input780/X
+ input791/X bank_A_sram.gen_ihp_256x32.u_sram_256x32_1087/L_LO bank_A_sram.gen_ihp_256x32.u_sram_256x32_1068/L_LO
+ bank_A_sram.gen_ihp_256x32.u_sram_256x32/A_BM[25] bank_A_sram.gen_ihp_256x32.u_sram_256x32/A_BM[6]
+ bank_A_sram.gen_ihp_256x32.u_sram_256x32_1054/L_LO bank_A_sram.gen_ihp_256x32.u_sram_256x32_1035/L_LO
+ wire995/A wire980/A input781/X input790/X bank_A_sram.gen_ihp_256x32.u_sram_256x32_1088/L_LO
+ bank_A_sram.gen_ihp_256x32.u_sram_256x32_1067/L_LO bank_A_sram.gen_ihp_256x32.u_sram_256x32/A_BM[26]
+ bank_A_sram.gen_ihp_256x32.u_sram_256x32/A_BM[5] bank_A_sram.gen_ihp_256x32.u_sram_256x32_1055/L_LO
+ bank_A_sram.gen_ihp_256x32.u_sram_256x32_1034/L_LO wire994/A wire982/A input782/X
+ input789/X bank_A_sram.gen_ihp_256x32.u_sram_256x32_1089/L_LO bank_A_sram.gen_ihp_256x32.u_sram_256x32_1066/L_LO
+ bank_A_sram.gen_ihp_256x32.u_sram_256x32/A_BM[27] bank_A_sram.gen_ihp_256x32.u_sram_256x32/A_BM[4]
+ bank_A_sram.gen_ihp_256x32.u_sram_256x32_1056/L_LO bank_A_sram.gen_ihp_256x32.u_sram_256x32_1033/L_LO
+ wire993/A wire984/A input783/X input788/X bank_A_sram.gen_ihp_256x32.u_sram_256x32_1090/L_LO
+ bank_A_sram.gen_ihp_256x32.u_sram_256x32_1065/L_LO bank_A_sram.gen_ihp_256x32.u_sram_256x32/A_BM[28]
+ bank_A_sram.gen_ihp_256x32.u_sram_256x32/A_BM[3] bank_A_sram.gen_ihp_256x32.u_sram_256x32_1057/L_LO
+ bank_A_sram.gen_ihp_256x32.u_sram_256x32_1032/L_LO _5334_/A wire986/A input784/X
+ input785/X bank_A_sram.gen_ihp_256x32.u_sram_256x32_1091/L_LO bank_A_sram.gen_ihp_256x32.u_sram_256x32_1064/L_LO
+ bank_A_sram.gen_ihp_256x32.u_sram_256x32/A_BM[29] bank_A_sram.gen_ihp_256x32.u_sram_256x32/A_BM[2]
+ bank_A_sram.gen_ihp_256x32.u_sram_256x32_1058/L_LO bank_A_sram.gen_ihp_256x32.u_sram_256x32_1031/L_LO
+ wire991/A wire990/A input786/X input774/X bank_A_sram.gen_ihp_256x32.u_sram_256x32_1092/L_LO
+ bank_A_sram.gen_ihp_256x32.u_sram_256x32_1063/L_LO bank_A_sram.gen_ihp_256x32.u_sram_256x32/A_BM[30]
+ bank_A_sram.gen_ihp_256x32.u_sram_256x32/A_BM[1] bank_A_sram.gen_ihp_256x32.u_sram_256x32_1059/L_LO
+ bank_A_sram.gen_ihp_256x32.u_sram_256x32_1030/L_LO wire988/A wire1002/A input787/X
+ input763/X bank_A_sram.gen_ihp_256x32.u_sram_256x32_1093/L_LO bank_A_sram.gen_ihp_256x32.u_sram_256x32_1062/L_LO
+ bank_A_sram.gen_ihp_256x32.u_sram_256x32/A_BM[31] bank_A_sram.gen_ihp_256x32.u_sram_256x32/A_BM[0]
+ bank_A_sram.gen_ihp_256x32.u_sram_256x32_1060/L_LO bank_A_sram.gen_ihp_256x32.u_sram_256x32_1029/L_LO
+ output893/A wire1020/A input755/X bank_A_sram.gen_ihp_256x32.u_sram_256x32_1021/L_LO
+ input756/X bank_A_sram.gen_ihp_256x32.u_sram_256x32_1022/L_LO input757/X bank_A_sram.gen_ihp_256x32.u_sram_256x32_1023/L_LO
+ input758/X bank_A_sram.gen_ihp_256x32.u_sram_256x32_1024/L_LO input759/X bank_A_sram.gen_ihp_256x32.u_sram_256x32_1025/L_LO
+ input760/X bank_A_sram.gen_ihp_256x32.u_sram_256x32_1026/L_LO input761/X bank_A_sram.gen_ihp_256x32.u_sram_256x32_1027/L_LO
+ input762/X bank_A_sram.gen_ihp_256x32.u_sram_256x32_1028/L_LO clkbuf_1_1__f_clk_i/X
+ _3927_/Y _3927_/A bank_A_sram.gen_ihp_256x32.u_sram_256x32/A_MEN bank_A_sram.gen_ihp_256x32.u_sram_256x32/A_DLY
+ bank_A_sram.gen_ihp_256x32.u_sram_256x32_1094/L_LO bank_A_sram.gen_ihp_256x32.u_sram_256x32_1061/L_LO
+ bank_A_sram.gen_ihp_256x32.u_sram_256x32_1096/L_LO bank_A_sram.gen_ihp_256x32.u_sram_256x32_1097/L_LO
+ bank_A_sram.gen_ihp_256x32.u_sram_256x32_1095/L_LO RM_IHPSG13_1P_256x32_c2_bm_bist
X_6356_ _6507_/A _6356_/A _6407_/B _6499_/C VDD VSS sg13cmos5l_nand3_1
X_5307_ _5307_/Y _5307_/A _5307_/B VDD VSS sg13cmos5l_nor2_1
XFILLER_88_402 VDD VSS sg13cmos5l_fill_1
X_6287_ _6288_/B _6287_/A _7661_/Q _6802_/B VDD VSS sg13cmos5l_nand3_1
XFILLER_88_435 VDD VSS sg13cmos5l_decap_8
XFILLER_57_800 VDD VSS sg13cmos5l_decap_8
XFILLER_57_811 VDD VSS sg13cmos5l_decap_8
XFILLER_75_107 VDD VSS sg13cmos5l_fill_2
X_5238_ _5239_/B _5238_/A _5238_/B VDD VSS sg13cmos5l_nand2_1
XFILLER_56_332 VDD VSS sg13cmos5l_fill_1
XFILLER_68_170 VDD VSS sg13cmos5l_decap_4
X_5169_ _5169_/Y _5106_/B _5107_/A _5168_/Y VDD VSS sg13cmos5l_o21ai_1
XFILLER_17_11 VDD VSS sg13cmos5l_decap_8
XFILLER_44_505 VDD VSS sg13cmos5l_decap_4
XFILLER_56_343 VDD VSS sg13cmos5l_fill_1
XFILLER_57_888 VDD VSS sg13cmos5l_decap_8
XFILLER_84_674 VDD VSS sg13cmos5l_decap_8
XFILLER_83_173 VDD VSS sg13cmos5l_decap_8
XFILLER_44_549 VDD VSS sg13cmos5l_decap_4
XFILLER_71_357 VDD VSS sg13cmos5l_decap_4
XFILLER_72_858 VDD VSS sg13cmos5l_decap_8
XFILLER_40_722 VDD VSS sg13cmos5l_fill_1
XFILLER_40_788 VDD VSS sg13cmos5l_decap_8
XFILLER_67_619 VDD VSS sg13cmos5l_decap_8
XFILLER_59_181 VDD VSS sg13cmos5l_fill_1
Xinput763 input763/X bank_A_wdata[0] VDD VSS sg13cmos5l_buf_1
Xinput774 input774/X bank_A_wdata[1] VDD VSS sg13cmos5l_buf_1
XFILLER_48_877 VDD VSS sg13cmos5l_decap_8
Xinput785 input785/X bank_A_wdata[2] VDD VSS sg13cmos5l_buf_1
Xinput796 _6187_/A bank_B_addr[0] VDD VSS sg13cmos5l_buf_1
XFILLER_75_652 VDD VSS sg13cmos5l_decap_8
XFILLER_63_847 VDD VSS sg13cmos5l_decap_8
XFILLER_74_151 VDD VSS sg13cmos5l_fill_1
XFILLER_74_61 VDD VSS sg13cmos5l_decap_4
XFILLER_74_83 VDD VSS sg13cmos5l_fill_2
X_4540_ _4553_/A _4460_/B _4460_/A _4539_/X VDD VSS sg13cmos5l_a21o_1
X_4471_ _4473_/A _4471_/A _4471_/B VDD VSS sg13cmos5l_nor2_1
X_7190_ _7190_/Y _7188_/Y _7298_/A1 _7297_/A VDD VSS sg13cmos5l_a21oi_1
X_6210_ _6211_/A _6210_/A input836/X VDD VSS sg13cmos5l_nor2b_1
Xrebuffer1416 rebuffer1416/X rebuffer1417/X VDD VSS sg13cmos5l_buf_1
Xrebuffer1405 rebuffer1405/X rebuffer1406/X VDD VSS sg13cmos5l_buf_1
X_6141_ _6143_/A _6163_/A _6141_/B VDD VSS sg13cmos5l_xnor2_1
Xrebuffer1449 rebuffer1449/X rebuffer1450/X VDD VSS sg13cmos5l_buf_1
Xrebuffer1438 rebuffer1438/X rebuffer1439/X VDD VSS sg13cmos5l_buf_2
Xrebuffer1427 _6880_/B _6513_/A VDD VSS sg13cmos5l_buf_1
XFILLER_86_906 VDD VSS sg13cmos5l_decap_8
XFILLER_24_0 VDD VSS sg13cmos5l_fill_2
X_6072_ _6103_/B _6168_/A _6072_/B VDD VSS sg13cmos5l_xnor2_1
XFILLER_86_917 VDD VSS sg13cmos5l_fill_1
XFILLER_66_630 VDD VSS sg13cmos5l_decap_4
X_5023_ _5024_/B _5023_/A _5092_/B VDD VSS sg13cmos5l_xor2_1
XFILLER_85_427 VDD VSS sg13cmos5l_fill_1
XFILLER_39_855 VDD VSS sg13cmos5l_decap_8
XFILLER_65_140 VDD VSS sg13cmos5l_decap_4
XFILLER_66_652 VDD VSS sg13cmos5l_decap_8
XFILLER_66_674 VDD VSS sg13cmos5l_decap_8
XFILLER_53_346 VDD VSS sg13cmos5l_decap_8
X_6974_ _6974_/Y _6974_/A _6974_/B VDD VSS sg13cmos5l_nand2_1
XFILLER_81_644 VDD VSS sg13cmos5l_decap_8
XFILLER_53_379 VDD VSS sg13cmos5l_fill_2
XFILLER_62_880 VDD VSS sg13cmos5l_decap_8
X_5925_ _5967_/A _5925_/A _5937_/A VDD VSS sg13cmos5l_xor2_1
X_5856_ _5923_/B _5854_/Y _5820_/B _5855_/Y VDD VSS sg13cmos5l_o21ai_1
X_4807_ _4807_/Y _4807_/A _4774_/B VDD VSS sg13cmos5l_nor2b_1
X_5787_ _7694_/D _5787_/A _5846_/A VDD VSS sg13cmos5l_nor2b_1
X_7526_ _7618_/A _7526_/A _7526_/B VDD VSS sg13cmos5l_xnor2_1
X_4738_ _4798_/S _4738_/A1 _5050_/A2 _4738_/B1 _4920_/B2 VDD VSS sg13cmos5l_a22oi_1
X_7457_ _7492_/B _7451_/B _7460_/A VDD VSS sg13cmos5l_nand2b_1
X_4669_ _4727_/A _4613_/A _4612_/Y _4668_/X VDD VSS sg13cmos5l_a21o_1
X_6408_ _6410_/B _6621_/A _6688_/B VDD VSS sg13cmos5l_nand2_1
X_7388_ _7509_/A _7388_/A VDD VSS sg13cmos5l_inv_1
X_6339_ _6790_/A _6339_/A _6341_/B VDD VSS sg13cmos5l_nor2b_2
XFILLER_88_243 VDD VSS sg13cmos5l_decap_4
XFILLER_88_210 VDD VSS sg13cmos5l_decap_4
Xrebuffer1972 rebuffer1972/X rebuffer1973/X VDD VSS sg13cmos5l_buf_1
Xrebuffer1961 rebuffer1961/X rebuffer1962/X VDD VSS sg13cmos5l_buf_1
Xrebuffer1950 rebuffer1950/X _5618_/A VDD VSS sg13cmos5l_buf_1
Xrebuffer1994 rebuffer1994/X rebuffer1995/X VDD VSS sg13cmos5l_buf_1
Xrebuffer1983 rebuffer1983/X rebuffer1984/X VDD VSS sg13cmos5l_buf_1
XFILLER_45_869 VDD VSS sg13cmos5l_decap_8
XFILLER_72_666 VDD VSS sg13cmos5l_decap_8
XFILLER_44_31 VDD VSS sg13cmos5l_decap_4
XFILLER_60_839 VDD VSS sg13cmos5l_decap_8
XFILLER_40_530 VDD VSS sg13cmos5l_fill_1
XFILLER_44_97 VDD VSS sg13cmos5l_decap_8
XFILLER_60_74 VDD VSS sg13cmos5l_decap_8
XFILLER_69_50 VDD VSS sg13cmos5l_decap_8
XFILLER_69_72 VDD VSS sg13cmos5l_decap_8
XFILLER_79_232 VDD VSS sg13cmos5l_fill_1
XFILLER_68_917 VDD VSS sg13cmos5l_fill_1
XFILLER_79_265 VDD VSS sg13cmos5l_fill_2
XFILLER_82_408 VDD VSS sg13cmos5l_decap_4
XFILLER_48_685 VDD VSS sg13cmos5l_fill_1
XFILLER_85_93 VDD VSS sg13cmos5l_fill_2
Xplace600 _5179_/A2 _5623_/A2 VDD VSS sg13cmos5l_buf_1
Xplace611 _5009_/A2 _3999_/A VDD VSS sg13cmos5l_buf_1
Xplace622 _5012_/B1 _5204_/B1 VDD VSS sg13cmos5l_buf_1
XFILLER_51_806 VDD VSS sg13cmos5l_fill_1
XFILLER_51_839 VDD VSS sg13cmos5l_decap_8
Xplace633 _4748_/A1 wire975/X VDD VSS sg13cmos5l_buf_1
Xplace644 _5901_/B1 _5395_/A VDD VSS sg13cmos5l_buf_1
Xplace655 _5558_/B1 _4766_/A VDD VSS sg13cmos5l_buf_1
X_3971_ _3987_/A _5645_/A _3970_/A _3970_/Y VDD VSS sg13cmos5l_a21oi_1
XFILLER_62_198 VDD VSS sg13cmos5l_decap_8
Xplace666 _7603_/A _7460_/A VDD VSS sg13cmos5l_buf_1
Xplace677 _7246_/A _7235_/B VDD VSS sg13cmos5l_buf_1
Xplace688 _7178_/S _7108_/S VDD VSS sg13cmos5l_buf_1
Xplace699 _7085_/B _7082_/B VDD VSS sg13cmos5l_buf_1
X_5710_ _5754_/B _5710_/A _5710_/B VDD VSS sg13cmos5l_nand2_1
X_6690_ _6690_/Y _6690_/A _6689_/A VDD VSS sg13cmos5l_nor2b_1
X_5641_ _5642_/B _5395_/A _3996_/Y _5641_/B1 _4017_/Y VDD VSS sg13cmos5l_a22oi_1
X_7311_ _7312_/A _7311_/A _7311_/B VDD VSS sg13cmos5l_nand2_1
X_4523_ _4526_/A _3964_/A _4524_/A _5204_/B1 VDD VSS sg13cmos5l_a21oi_1
X_7242_ _7257_/A _6630_/A _7234_/Y _7241_/Y VDD VSS sg13cmos5l_o21ai_1
X_4454_ _4455_/B _4506_/A _4454_/B VDD VSS sg13cmos5l_xnor2_1
X_7173_ _7174_/B _7167_/Y _7350_/A2 _7172_/Y VDD VSS sg13cmos5l_a21oi_1
X_4385_ _4396_/A _4643_/A _4385_/B VDD VSS sg13cmos5l_xnor2_1
Xrebuffer1246 _6561_/B _6277_/B VDD VSS sg13cmos5l_buf_1
Xrebuffer1257 _7510_/A rebuffer1343/X VDD VSS sg13cmos5l_buf_1
Xrebuffer1268 _7519_/A rebuffer1335/X VDD VSS sg13cmos5l_buf_1
X_6124_ _6124_/Y _6124_/A _6124_/B VDD VSS sg13cmos5l_nand2_1
XFILLER_86_703 VDD VSS sg13cmos5l_decap_8
Xrebuffer1279 rebuffer1279/X rebuffer1280/X VDD VSS sg13cmos5l_buf_1
XFILLER_85_235 VDD VSS sg13cmos5l_decap_8
XFILLER_85_202 VDD VSS sg13cmos5l_fill_1
XFILLER_39_641 VDD VSS sg13cmos5l_fill_2
X_5006_ _5022_/A _5006_/A _5006_/B VDD VSS sg13cmos5l_xor2_1
XFILLER_38_140 VDD VSS sg13cmos5l_fill_2
XFILLER_38_151 VDD VSS sg13cmos5l_fill_2
XFILLER_39_685 VDD VSS sg13cmos5l_decap_4
XFILLER_54_611 VDD VSS sg13cmos5l_fill_1
XFILLER_54_633 VDD VSS sg13cmos5l_decap_4
XFILLER_41_305 VDD VSS sg13cmos5l_decap_4
XFILLER_53_165 VDD VSS sg13cmos5l_decap_4
XFILLER_54_666 VDD VSS sg13cmos5l_fill_1
X_6957_ _6958_/B _6827_/Y _6824_/A _6957_/S VDD VSS sg13cmos5l_mux2_1
X_6888_ _6888_/Y _7164_/A _7101_/A VDD VSS sg13cmos5l_nor2_1
X_5908_ _5916_/A _5862_/B _5547_/A _5908_/S VDD VSS sg13cmos5l_mux2_1
XFILLER_50_883 VDD VSS sg13cmos5l_decap_8
X_5839_ _5843_/B _5884_/A _5885_/A VDD VSS sg13cmos5l_xnor2_1
X_7509_ _7511_/A _7509_/A _7509_/B VDD VSS sg13cmos5l_nand2_1
XFILLER_49_416 VDD VSS sg13cmos5l_decap_8
XFILLER_49_449 VDD VSS sg13cmos5l_decap_8
XFILLER_76_224 VDD VSS sg13cmos5l_fill_2
XFILLER_39_86 VDD VSS sg13cmos5l_decap_8
XFILLER_76_246 VDD VSS sg13cmos5l_decap_8
XFILLER_45_633 VDD VSS sg13cmos5l_decap_8
XFILLER_44_143 VDD VSS sg13cmos5l_decap_8
XFILLER_45_666 VDD VSS sg13cmos5l_decap_8
XFILLER_45_677 VDD VSS sg13cmos5l_fill_1
XFILLER_72_441 VDD VSS sg13cmos5l_decap_8
XFILLER_60_625 VDD VSS sg13cmos5l_fill_1
XFILLER_41_894 VDD VSS sg13cmos5l_decap_8
XFILLER_71_62 VDD VSS sg13cmos5l_fill_2
XFILLER_68_703 VDD VSS sg13cmos5l_fill_1
X_4170_ _4173_/A _3955_/A _4171_/A _3960_/Y VDD VSS sg13cmos5l_a21oi_1
XFILLER_68_736 VDD VSS sg13cmos5l_decap_8
XFILLER_68_747 VDD VSS sg13cmos5l_fill_1
XFILLER_76_791 VDD VSS sg13cmos5l_decap_8
XFILLER_63_474 VDD VSS sg13cmos5l_fill_2
X_6811_ _6811_/Y _6811_/A _6811_/B VDD VSS sg13cmos5l_xnor2_1
X_6742_ _6744_/A _6742_/A _6742_/B VDD VSS sg13cmos5l_nand2_1
X_3954_ _3967_/A _3970_/A _3968_/A VDD VSS sg13cmos5l_nand2_1
XFILLER_91_0 VDD VSS sg13cmos5l_fill_2
X_6673_ _6675_/A _6674_/A _6684_/C _7703_/Q VDD VSS sg13cmos5l_a21oi_1
X_5624_ _5625_/B _5747_/A _5624_/B VDD VSS sg13cmos5l_xnor2_1
Xbank_A_sram.gen_ihp_256x32.u_sram_256x32_1202 bank_A_sram.gen_ihp_256x32.u_sram_256x32/A_BM[27]
+ VDD VSS sg13cmos5l_tiehi
X_5555_ _5660_/A _5500_/B _5500_/A _5554_/Y VDD VSS sg13cmos5l_a21oi_1
X_5486_ _5489_/B _5419_/A _5419_/B _5420_/A VDD VSS sg13cmos5l_o21ai_1
X_4506_ _4506_/Y _4506_/A _4454_/B VDD VSS sg13cmos5l_nor2b_1
Xoutput864 act_out[3] _6220_/Y VDD VSS sg13cmos5l_buf_1
X_7225_ _7226_/A _7225_/A _7233_/B _7225_/C VDD VSS sg13cmos5l_nand3_1
X_4437_ _4500_/B _4692_/A _4437_/B VDD VSS sg13cmos5l_xnor2_1
Xoutput875 bank_A_rdata[15] _4524_/A VDD VSS sg13cmos5l_buf_1
Xoutput886 bank_A_rdata[25] wire995/A VDD VSS sg13cmos5l_buf_1
Xoutput897 bank_A_rdata[6] _4056_/A VDD VSS sg13cmos5l_buf_1
X_7156_ _7156_/Y _7246_/A _7156_/B VDD VSS sg13cmos5l_nor2_1
XFILLER_58_224 VDD VSS sg13cmos5l_decap_8
X_6107_ _6109_/A _6123_/B _6107_/B VDD VSS sg13cmos5l_nor2_1
X_4368_ _4417_/B _6110_/B _4368_/B VDD VSS sg13cmos5l_xnor2_1
XFILLER_76_29 VDD VSS sg13cmos5l_decap_8
Xbank_B_sram.gen_ihp_256x32.u_sram_256x32_1211 bank_B_sram.gen_ihp_256x32.u_sram_256x32/A_BM[2]
+ VDD VSS sg13cmos5l_tiehi
Xbank_B_sram.gen_ihp_256x32.u_sram_256x32_1222 bank_B_sram.gen_ihp_256x32.u_sram_256x32/A_BM[13]
+ VDD VSS sg13cmos5l_tiehi
X_7087_ _7087_/Y _7087_/A _7087_/B VDD VSS sg13cmos5l_nor2_1
X_4299_ _6111_/B _4374_/A _4300_/B VDD VSS sg13cmos5l_nor2_1
XFILLER_39_460 VDD VSS sg13cmos5l_decap_8
XFILLER_74_728 VDD VSS sg13cmos5l_decap_8
Xbank_B_sram.gen_ihp_256x32.u_sram_256x32_1233 bank_B_sram.gen_ihp_256x32.u_sram_256x32/A_BM[24]
+ VDD VSS sg13cmos5l_tiehi
X_6038_ _6048_/A _5996_/B _6036_/Y _6037_/Y VDD VSS sg13cmos5l_a21oi_1
XFILLER_86_577 VDD VSS sg13cmos5l_decap_8
XFILLER_42_603 VDD VSS sg13cmos5l_fill_2
XFILLER_42_625 VDD VSS sg13cmos5l_decap_8
XFILLER_82_783 VDD VSS sg13cmos5l_decap_8
XFILLER_41_179 VDD VSS sg13cmos5l_fill_2
XFILLER_50_680 VDD VSS sg13cmos5l_fill_2
XFILLER_41_98 VDD VSS sg13cmos5l_decap_8
Xwire969 wire969/X wire969/A VDD VSS sg13cmos5l_buf_2
XFILLER_2_15 VDD VSS sg13cmos5l_decap_4
XFILLER_73_750 VDD VSS sg13cmos5l_fill_2
XFILLER_45_496 VDD VSS sg13cmos5l_fill_1
XFILLER_82_50 VDD VSS sg13cmos5l_decap_4
X_5340_ _5341_/B _5389_/A _5389_/B VDD VSS sg13cmos5l_xor2_1
X_5271_ _5281_/A _5757_/A _5271_/B VDD VSS sg13cmos5l_xnor2_1
X_7010_ _7096_/A _7010_/A _7059_/A VDD VSS sg13cmos5l_nand2_2
X_4222_ _4223_/B _4127_/A _4592_/A2 _4434_/B1 _4531_/B2 VDD VSS sg13cmos5l_a22oi_1
XFILLER_68_522 VDD VSS sg13cmos5l_fill_1
XFILLER_87_319 VDD VSS sg13cmos5l_fill_2
XFILLER_68_544 VDD VSS sg13cmos5l_decap_4
X_4153_ _4153_/Y _4153_/A _4153_/B VDD VSS sg13cmos5l_nand2_1
X_4084_ _4087_/A _3955_/A _4085_/A _3960_/Y VDD VSS sg13cmos5l_a21oi_1
XFILLER_52_901 VDD VSS sg13cmos5l_decap_8
XFILLER_51_411 VDD VSS sg13cmos5l_fill_1
X_4986_ _5049_/S _5050_/B1 _5050_/A2 _4986_/B1 _5370_/B2 VDD VSS sg13cmos5l_a22oi_1
X_6725_ _6726_/A _6721_/Y _6901_/A _6724_/X VDD VSS sg13cmos5l_a21oi_1
X_6656_ _6664_/A _6656_/A _6656_/B VDD VSS sg13cmos5l_nand2_1
X_6587_ _6603_/A _6587_/A _6587_/B VDD VSS sg13cmos5l_nor2_2
X_5607_ _5609_/A _5608_/A _5608_/C _5608_/B VDD VSS sg13cmos5l_a21o_1
X_5538_ _5541_/A _5538_/A VDD VSS sg13cmos5l_inv_1
Xbank_A_sram.gen_ihp_256x32.u_sram_256x32_1021 bank_A_sram.gen_ihp_256x32.u_sram_256x32_1021/L_LO
+ VDD VSS sg13cmos5l_tielo
Xbank_A_sram.gen_ihp_256x32.u_sram_256x32_1032 bank_A_sram.gen_ihp_256x32.u_sram_256x32_1032/L_LO
+ VDD VSS sg13cmos5l_tielo
Xbank_A_sram.gen_ihp_256x32.u_sram_256x32_1043 bank_A_sram.gen_ihp_256x32.u_sram_256x32_1043/L_LO
+ VDD VSS sg13cmos5l_tielo
XFILLER_2_8 VDD VSS sg13cmos5l_decap_8
Xbank_A_sram.gen_ihp_256x32.u_sram_256x32_1054 bank_A_sram.gen_ihp_256x32.u_sram_256x32_1054/L_LO
+ VDD VSS sg13cmos5l_tielo
Xbank_A_sram.gen_ihp_256x32.u_sram_256x32_1065 bank_A_sram.gen_ihp_256x32.u_sram_256x32_1065/L_LO
+ VDD VSS sg13cmos5l_tielo
Xbank_A_sram.gen_ihp_256x32.u_sram_256x32_1076 bank_A_sram.gen_ihp_256x32.u_sram_256x32_1076/L_LO
+ VDD VSS sg13cmos5l_tielo
Xbank_A_sram.gen_ihp_256x32.u_sram_256x32_1087 bank_A_sram.gen_ihp_256x32.u_sram_256x32_1087/L_LO
+ VDD VSS sg13cmos5l_tielo
X_7208_ _7208_/Y _7298_/A1 _6859_/Y _7207_/Y VDD VSS sg13cmos5l_o21ai_1
X_5469_ _5470_/B _5469_/A _5531_/B VDD VSS sg13cmos5l_xor2_1
X_7139_ _7296_/B _7168_/B _6959_/Y _7138_/Y VDD VSS sg13cmos5l_o21ai_1
XFILLER_87_864 VDD VSS sg13cmos5l_decap_8
XFILLER_46_216 VDD VSS sg13cmos5l_fill_1
XFILLER_46_249 VDD VSS sg13cmos5l_fill_1
XFILLER_54_271 VDD VSS sg13cmos5l_decap_8
XFILLER_82_580 VDD VSS sg13cmos5l_decap_8
XFILLER_78_842 VDD VSS sg13cmos5l_decap_8
XFILLER_77_61 VDD VSS sg13cmos5l_fill_1
XFILLER_77_363 VDD VSS sg13cmos5l_decap_4
XFILLER_46_772 VDD VSS sg13cmos5l_fill_2
XFILLER_46_783 VDD VSS sg13cmos5l_decap_4
X_4840_ _4841_/B _4840_/A _4840_/B VDD VSS sg13cmos5l_xor2_1
XFILLER_61_775 VDD VSS sg13cmos5l_fill_1
X_6510_ _6510_/X _6518_/C _6518_/B VDD VSS sg13cmos5l_and2_1
X_4771_ _4818_/B _5018_/A _4771_/B VDD VSS sg13cmos5l_xnor2_1
X_7490_ _7629_/B _7605_/B _7605_/A VDD VSS sg13cmos5l_xnor2_1
X_6441_ _6457_/A _6441_/A _6441_/B VDD VSS sg13cmos5l_nor2_2
X_6372_ _6375_/B _6372_/A _7669_/Q _6372_/C VDD VSS sg13cmos5l_nand3_1
X_5323_ _5374_/A _5442_/A _5323_/B VDD VSS sg13cmos5l_xnor2_1
X_5254_ _5284_/A _5214_/B _5214_/A _5253_/Y VDD VSS sg13cmos5l_a21oi_1
XFILLER_88_628 VDD VSS sg13cmos5l_fill_1
XFILLER_87_116 VDD VSS sg13cmos5l_decap_8
XFILLER_69_864 VDD VSS sg13cmos5l_decap_8
X_5185_ _5286_/B _5185_/A _5185_/B VDD VSS sg13cmos5l_xor2_1
XFILLER_68_374 VDD VSS sg13cmos5l_decap_8
X_4136_ _4148_/A _4181_/A _4136_/B VDD VSS sg13cmos5l_xnor2_1
XFILLER_84_856 VDD VSS sg13cmos5l_decap_8
X_4067_ _4108_/B _4067_/A _4067_/B VDD VSS sg13cmos5l_nor2_1
XFILLER_83_344 VDD VSS sg13cmos5l_decap_4
XFILLER_43_208 VDD VSS sg13cmos5l_decap_4
XFILLER_83_377 VDD VSS sg13cmos5l_decap_8
XFILLER_52_742 VDD VSS sg13cmos5l_fill_2
XFILLER_64_591 VDD VSS sg13cmos5l_fill_1
XFILLER_51_285 VDD VSS sg13cmos5l_decap_4
X_4969_ _4970_/B _4969_/A _4969_/B VDD VSS sg13cmos5l_nand2_1
XFILLER_22_12 VDD VSS sg13cmos5l_decap_8
X_7688_ _7688_/Q _7704_/CLK _7688_/D place754/X VDD VSS sg13cmos5l_dfrbpq_1
X_6708_ _6713_/A _6779_/A _6780_/C VDD VSS sg13cmos5l_nand2_1
X_6639_ _6641_/A _6647_/C _6647_/A VDD VSS sg13cmos5l_xnor2_1
XFILLER_79_617 VDD VSS sg13cmos5l_fill_1
XFILLER_59_363 VDD VSS sg13cmos5l_decap_4
Xfanout151 _5630_/A _5381_/A VDD VSS sg13cmos5l_buf_1
XFILLER_87_661 VDD VSS sg13cmos5l_decap_8
XFILLER_74_300 VDD VSS sg13cmos5l_fill_2
Xfanout195 _4374_/A _4508_/A VDD VSS sg13cmos5l_buf_1
XFILLER_86_182 VDD VSS sg13cmos5l_fill_1
XFILLER_75_856 VDD VSS sg13cmos5l_decap_8
XFILLER_42_252 VDD VSS sg13cmos5l_decap_4
XFILLER_63_96 VDD VSS sg13cmos5l_decap_8
XFILLER_88_60 VDD VSS sg13cmos5l_fill_1
XFILLER_69_138 VDD VSS sg13cmos5l_fill_2
XFILLER_38_536 VDD VSS sg13cmos5l_decap_8
XFILLER_66_845 VDD VSS sg13cmos5l_decap_8
XFILLER_78_683 VDD VSS sg13cmos5l_decap_8
XFILLER_65_333 VDD VSS sg13cmos5l_fill_1
XFILLER_65_344 VDD VSS sg13cmos5l_decap_4
X_6990_ _6991_/A _6990_/A _7054_/B _6990_/C VDD VSS sg13cmos5l_nand3_1
XFILLER_65_388 VDD VSS sg13cmos5l_decap_8
XFILLER_65_399 VDD VSS sg13cmos5l_fill_1
X_5941_ _5942_/B _6082_/A1 _5981_/A2 _6082_/B1 _5981_/B2 VDD VSS sg13cmos5l_a22oi_1
XFILLER_81_826 VDD VSS sg13cmos5l_decap_8
XFILLER_80_314 VDD VSS sg13cmos5l_fill_2
XFILLER_80_347 VDD VSS sg13cmos5l_decap_8
X_5872_ _5913_/B _5977_/B _5872_/B VDD VSS sg13cmos5l_xnor2_1
X_7611_ _7612_/B _7611_/A _7611_/B VDD VSS sg13cmos5l_xnor2_1
X_7542_ _7544_/A _7542_/A _7542_/B VDD VSS sg13cmos5l_nand2_1
X_4754_ _4803_/A _4871_/A _4754_/B VDD VSS sg13cmos5l_xnor2_1
X_7473_ _7480_/A _7473_/A _7603_/A _7477_/B _7478_/B VDD VSS sg13cmos5l_nand4_1
X_4685_ _4711_/A _4655_/B _4655_/A _4684_/Y VDD VSS sg13cmos5l_a21oi_1
X_6424_ _6820_/A _6424_/A VDD VSS sg13cmos5l_inv_1
XFILLER_68_19 VDD VSS sg13cmos5l_decap_4
X_6286_ _6288_/A _6286_/A _6286_/B VDD VSS sg13cmos5l_nand2_2
X_5306_ _5412_/A _5252_/B _5252_/A _5305_/Y VDD VSS sg13cmos5l_a21oi_1
X_5237_ _5239_/A _5221_/A _5237_/B VDD VSS sg13cmos5l_nand2b_1
XFILLER_88_458 VDD VSS sg13cmos5l_fill_1
XFILLER_88_447 VDD VSS sg13cmos5l_decap_8
X_5168_ _5168_/Y _5101_/A _5104_/Y _5101_/B VDD VSS sg13cmos5l_o21ai_1
XFILLER_57_867 VDD VSS sg13cmos5l_decap_8
X_5099_ _5108_/A _5109_/B _5109_/A VDD VSS sg13cmos5l_xor2_1
X_4119_ _4181_/A _4153_/B _4153_/A VDD VSS sg13cmos5l_xor2_1
XFILLER_84_653 VDD VSS sg13cmos5l_decap_8
XFILLER_72_837 VDD VSS sg13cmos5l_decap_8
XFILLER_71_369 VDD VSS sg13cmos5l_decap_4
XFILLER_52_583 VDD VSS sg13cmos5l_fill_2
XFILLER_80_892 VDD VSS sg13cmos5l_decap_8
XFILLER_40_767 VDD VSS sg13cmos5l_decap_8
XFILLER_58_30 VDD VSS sg13cmos5l_decap_4
XFILLER_58_41 VDD VSS sg13cmos5l_fill_1
Xinput764 input764/X bank_A_wdata[10] VDD VSS sg13cmos5l_buf_1
XFILLER_75_620 VDD VSS sg13cmos5l_fill_1
XFILLER_47_344 VDD VSS sg13cmos5l_fill_2
XFILLER_48_856 VDD VSS sg13cmos5l_decap_8
Xinput775 input775/X bank_A_wdata[20] VDD VSS sg13cmos5l_buf_1
Xinput786 input786/X bank_A_wdata[30] VDD VSS sg13cmos5l_buf_1
Xinput797 _6190_/B bank_B_addr[1] VDD VSS sg13cmos5l_buf_1
XFILLER_47_366 VDD VSS sg13cmos5l_decap_8
XFILLER_47_377 VDD VSS sg13cmos5l_fill_1
XFILLER_63_826 VDD VSS sg13cmos5l_decap_8
X_4470_ _4471_/B _4470_/A VDD VSS sg13cmos5l_inv_1
Xrebuffer1417 rebuffer1417/X rebuffer1418/X VDD VSS sg13cmos5l_buf_1
Xrebuffer1406 rebuffer1406/X rebuffer1407/X VDD VSS sg13cmos5l_buf_1
X_6140_ _6141_/B _6175_/B _6139_/A _6139_/Y VDD VSS sg13cmos5l_o21ai_1
Xrebuffer1439 rebuffer1439/X rebuffer1440/X VDD VSS sg13cmos5l_buf_1
Xrebuffer1428 rebuffer1428/X rebuffer1429/X VDD VSS sg13cmos5l_buf_1
XFILLER_58_609 VDD VSS sg13cmos5l_fill_2
X_6071_ _6072_/B _6100_/B _6100_/A VDD VSS sg13cmos5l_xnor2_1
XFILLER_38_311 VDD VSS sg13cmos5l_decap_8
XFILLER_39_834 VDD VSS sg13cmos5l_decap_8
X_5022_ _5092_/B _5022_/A _5022_/B VDD VSS sg13cmos5l_xor2_1
XFILLER_53_303 VDD VSS sg13cmos5l_decap_8
XFILLER_66_686 VDD VSS sg13cmos5l_decap_8
XFILLER_81_623 VDD VSS sg13cmos5l_decap_8
XFILLER_54_859 VDD VSS sg13cmos5l_decap_8
XFILLER_65_185 VDD VSS sg13cmos5l_fill_2
X_6973_ _6973_/Y _7078_/A _6976_/B _6972_/X VDD VSS sg13cmos5l_a21oi_1
X_5924_ _5937_/A _5881_/A _5922_/Y _5923_/Y VDD VSS sg13cmos5l_o21ai_1
X_5855_ _5855_/Y _5855_/A _5855_/B VDD VSS sg13cmos5l_nand2_1
X_4806_ _4900_/B _4806_/A _4806_/B VDD VSS sg13cmos5l_xor2_1
X_5786_ _5848_/A _5786_/A _5786_/B _5786_/C VDD VSS sg13cmos5l_nand3_1
X_7525_ _7526_/B _7525_/A _7525_/B VDD VSS sg13cmos5l_nand2_1
X_4668_ _4668_/X _4668_/A _4668_/B VDD VSS sg13cmos5l_and2_1
X_6407_ _6688_/B _6407_/A _6407_/B _6548_/B _6548_/C VDD VSS sg13cmos5l_nor4_1
X_7387_ _7388_/A _7570_/B _7387_/B VDD VSS sg13cmos5l_nor2_1
X_4599_ _4599_/Y _4599_/A _4599_/B VDD VSS sg13cmos5l_nand2_1
XFILLER_88_200 VDD VSS sg13cmos5l_fill_2
X_6338_ _6341_/B _7666_/Q _6338_/B _6372_/C VDD VSS sg13cmos5l_nand3_1
XFILLER_77_907 VDD VSS sg13cmos5l_decap_8
Xrebuffer1973 rebuffer1973/X rebuffer1974/X VDD VSS sg13cmos5l_buf_1
Xrebuffer1962 rebuffer1962/X rebuffer1963/X VDD VSS sg13cmos5l_buf_1
Xrebuffer1951 rebuffer1951/X rebuffer1952/X VDD VSS sg13cmos5l_buf_1
Xrebuffer1940 rebuffer1940/X rebuffer1941/X VDD VSS sg13cmos5l_buf_1
XFILLER_88_266 VDD VSS sg13cmos5l_decap_8
XFILLER_76_406 VDD VSS sg13cmos5l_fill_1
Xrebuffer1995 rebuffer1995/X rebuffer1996/X VDD VSS sg13cmos5l_buf_1
Xrebuffer1984 rebuffer1984/X rebuffer1985/X VDD VSS sg13cmos5l_buf_1
XFILLER_57_664 VDD VSS sg13cmos5l_fill_2
XFILLER_84_472 VDD VSS sg13cmos5l_decap_4
XFILLER_44_347 VDD VSS sg13cmos5l_decap_4
XFILLER_45_848 VDD VSS sg13cmos5l_decap_8
XFILLER_56_196 VDD VSS sg13cmos5l_fill_1
XFILLER_72_634 VDD VSS sg13cmos5l_fill_2
XFILLER_72_645 VDD VSS sg13cmos5l_fill_1
XFILLER_72_689 VDD VSS sg13cmos5l_fill_1
XFILLER_44_65 VDD VSS sg13cmos5l_fill_1
XFILLER_53_881 VDD VSS sg13cmos5l_decap_8
XFILLER_79_200 VDD VSS sg13cmos5l_decap_4
XFILLER_67_439 VDD VSS sg13cmos5l_decap_4
XFILLER_47_152 VDD VSS sg13cmos5l_decap_4
XFILLER_63_634 VDD VSS sg13cmos5l_fill_2
Xplace601 _5623_/A2 _4301_/Y VDD VSS sg13cmos5l_buf_1
Xplace612 _3999_/A _4167_/A2 VDD VSS sg13cmos5l_buf_1
Xplace623 _5204_/B1 _3976_/B VDD VSS sg13cmos5l_buf_1
XFILLER_75_483 VDD VSS sg13cmos5l_fill_2
XFILLER_62_155 VDD VSS sg13cmos5l_fill_2
XFILLER_63_667 VDD VSS sg13cmos5l_fill_2
Xplace634 _4686_/A1 wire977/X VDD VSS sg13cmos5l_buf_1
Xplace645 _5871_/B1 _5641_/B1 VDD VSS sg13cmos5l_buf_1
Xplace656 _5557_/A1 _4701_/A VDD VSS sg13cmos5l_buf_1
X_3970_ _3970_/Y _3970_/A _3970_/B VDD VSS sg13cmos5l_nor2_1
XFILLER_62_177 VDD VSS sg13cmos5l_decap_8
Xplace667 _7460_/A _7438_/A VDD VSS sg13cmos5l_buf_1
Xplace678 _7235_/B _6891_/B VDD VSS sg13cmos5l_buf_1
Xplace689 _7108_/S _7006_/B VDD VSS sg13cmos5l_buf_1
X_5640_ _5694_/A _5588_/Y _5590_/A _5589_/A VDD VSS sg13cmos5l_a21oi_1
X_5571_ _5578_/A _5630_/A _5571_/B VDD VSS sg13cmos5l_xnor2_1
X_7310_ _7317_/A _7310_/A _7310_/B VDD VSS sg13cmos5l_nand2_2
X_7241_ _7241_/Y _7241_/A _7290_/A VDD VSS sg13cmos5l_nor2_1
X_4453_ _4454_/B _4453_/A _4453_/B VDD VSS sg13cmos5l_xor2_1
X_7172_ _7172_/Y _7168_/Y _7169_/Y _7171_/Y _7296_/A _7327_/A VDD VSS sg13cmos5l_a221oi_1
X_4384_ _4385_/B wire975/X _3999_/A wire977/X _4642_/B2 VDD VSS sg13cmos5l_a22oi_1
Xrebuffer1247 _6277_/B _6244_/Y VDD VSS sg13cmos5l_buf_2
Xrebuffer1258 _7564_/B _7375_/A VDD VSS sg13cmos5l_buf_1
X_6123_ _6123_/Y _6089_/A _6123_/B VDD VSS sg13cmos5l_nand2b_1
Xrebuffer1269 _6287_/A _6284_/A VDD VSS sg13cmos5l_buf_1
X_6054_ _6123_/B _6052_/B _6111_/A _6052_/Y _6053_/Y VDD VSS sg13cmos5l_a22oi_1
XFILLER_39_653 VDD VSS sg13cmos5l_fill_2
X_5005_ _5006_/B _5054_/A _5054_/B VDD VSS sg13cmos5l_xor2_1
XFILLER_86_759 VDD VSS sg13cmos5l_decap_8
XFILLER_38_174 VDD VSS sg13cmos5l_decap_8
XFILLER_38_185 VDD VSS sg13cmos5l_fill_2
X_6956_ _6956_/Y _6955_/B _6822_/X _6955_/Y VDD VSS sg13cmos5l_o21ai_1
X_5907_ _5957_/B _5907_/A _5947_/B VDD VSS sg13cmos5l_xnor2_1
XFILLER_50_862 VDD VSS sg13cmos5l_decap_8
X_6887_ _7101_/A _7071_/B _7032_/A _6886_/Y VDD VSS sg13cmos5l_o21ai_1
X_5838_ _5885_/A _5838_/A _5838_/B VDD VSS sg13cmos5l_and2_1
X_5769_ _5769_/Y _5769_/A _5718_/A VDD VSS sg13cmos5l_nor2b_1
X_7508_ _7620_/B _7508_/A _7508_/B VDD VSS sg13cmos5l_xor2_1
X_7439_ _7441_/A _7439_/A _7587_/A _7583_/A VDD VSS sg13cmos5l_nand3_1
XFILLER_77_715 VDD VSS sg13cmos5l_fill_1
XFILLER_44_111 VDD VSS sg13cmos5l_decap_8
XFILLER_44_122 VDD VSS sg13cmos5l_fill_1
XFILLER_72_475 VDD VSS sg13cmos5l_decap_8
XFILLER_40_350 VDD VSS sg13cmos5l_fill_2
XFILLER_40_372 VDD VSS sg13cmos5l_fill_2
XFILLER_41_873 VDD VSS sg13cmos5l_decap_8
XFILLER_67_203 VDD VSS sg13cmos5l_decap_4
XFILLER_55_409 VDD VSS sg13cmos5l_fill_1
XFILLER_76_770 VDD VSS sg13cmos5l_decap_8
X_6810_ _6834_/A _6797_/Y _6808_/Y _6321_/B VDD VSS sg13cmos5l_a21oi_1
X_6741_ _6741_/Y _6740_/Y _6743_/A VDD VSS sg13cmos5l_nand2b_1
X_3953_ _3968_/A _3953_/A _4422_/A _5335_/A VDD VSS sg13cmos5l_nand3_1
X_6672_ _6674_/A _6681_/C _6681_/A VDD VSS sg13cmos5l_xnor2_1
X_5623_ _5624_/B _5792_/B1 _5623_/A2 _5745_/B1 _5687_/B2 VDD VSS sg13cmos5l_a22oi_1
X_5554_ _5554_/Y _5554_/A _5499_/A VDD VSS sg13cmos5l_nor2b_1
Xbank_A_sram.gen_ihp_256x32.u_sram_256x32_1203 bank_A_sram.gen_ihp_256x32.u_sram_256x32/A_BM[28]
+ VDD VSS sg13cmos5l_tiehi
X_5485_ _5489_/A _5485_/A _5485_/B VDD VSS sg13cmos5l_nand2_2
X_4505_ _4557_/A _4505_/A _4505_/B VDD VSS sg13cmos5l_xnor2_1
XFILLER_116_15 VDD VSS sg13cmos5l_decap_4
X_7224_ _7224_/Y _7299_/A1 _7369_/B _7223_/Y VDD VSS sg13cmos5l_o21ai_1
X_4436_ _4437_/B _4739_/B1 _4878_/A2 _4738_/A1 _4878_/B2 VDD VSS sg13cmos5l_a22oi_1
Xoutput865 act_out[4] _6222_/Y VDD VSS sg13cmos5l_buf_1
Xoutput876 bank_A_rdata[16] wire1006/A VDD VSS sg13cmos5l_buf_1
Xoutput887 bank_A_rdata[26] wire994/A VDD VSS sg13cmos5l_buf_1
X_7155_ _7156_/B _7108_/S _7006_/A _7154_/Y VDD VSS sg13cmos5l_o21ai_1
X_4367_ _4368_/B _3965_/B _4303_/A _4497_/B1 _4800_/B2 VDD VSS sg13cmos5l_a22oi_1
XFILLER_58_203 VDD VSS sg13cmos5l_decap_8
Xoutput898 bank_A_rdata[7] _4085_/A VDD VSS sg13cmos5l_buf_1
X_6106_ _6152_/B _6095_/A _6095_/B _6096_/A VDD VSS sg13cmos5l_a21oi_1
Xbank_B_sram.gen_ihp_256x32.u_sram_256x32_1212 bank_B_sram.gen_ihp_256x32.u_sram_256x32/A_BM[3]
+ VDD VSS sg13cmos5l_tiehi
X_7086_ _7086_/Y _7085_/B _6956_/Y _7085_/Y VDD VSS sg13cmos5l_o21ai_1
X_4298_ _4357_/A _4298_/A1 _4289_/B _4297_/X VDD VSS sg13cmos5l_a21o_1
XFILLER_86_556 VDD VSS sg13cmos5l_fill_2
Xbank_B_sram.gen_ihp_256x32.u_sram_256x32_1223 bank_B_sram.gen_ihp_256x32.u_sram_256x32/A_BM[14]
+ VDD VSS sg13cmos5l_tiehi
Xbank_B_sram.gen_ihp_256x32.u_sram_256x32_1234 bank_B_sram.gen_ihp_256x32.u_sram_256x32/A_BM[25]
+ VDD VSS sg13cmos5l_tiehi
X_6037_ _6037_/Y _6037_/A _6037_/B VDD VSS sg13cmos5l_nor2_1
XFILLER_82_762 VDD VSS sg13cmos5l_decap_8
X_6939_ _6939_/Y _6941_/B _6939_/B VDD VSS sg13cmos5l_nor2_1
XFILLER_77_556 VDD VSS sg13cmos5l_fill_1
XFILLER_49_269 VDD VSS sg13cmos5l_fill_1
XFILLER_65_707 VDD VSS sg13cmos5l_decap_8
XFILLER_64_239 VDD VSS sg13cmos5l_decap_4
XFILLER_66_85 VDD VSS sg13cmos5l_fill_2
XFILLER_57_291 VDD VSS sg13cmos5l_fill_1
XFILLER_73_740 VDD VSS sg13cmos5l_fill_1
XFILLER_60_423 VDD VSS sg13cmos5l_decap_8
XFILLER_60_434 VDD VSS sg13cmos5l_fill_2
XFILLER_82_73 VDD VSS sg13cmos5l_fill_1
XFILLER_41_670 VDD VSS sg13cmos5l_decap_8
X_5270_ _5271_/B _5013_/A _5514_/A2 _5859_/B1 _5756_/B2 VDD VSS sg13cmos5l_a22oi_1
X_4221_ _4269_/A _5335_/B _4171_/A _4220_/Y VDD VSS sg13cmos5l_a21o_1
XFILLER_87_309 VDD VSS sg13cmos5l_decap_8
XFILLER_68_501 VDD VSS sg13cmos5l_decap_8
X_4152_ _5944_/A _4266_/A VDD VSS sg13cmos5l_inv_1
XFILLER_55_206 VDD VSS sg13cmos5l_fill_2
XFILLER_83_548 VDD VSS sg13cmos5l_decap_8
XFILLER_48_291 VDD VSS sg13cmos5l_fill_2
XFILLER_64_773 VDD VSS sg13cmos5l_fill_2
XFILLER_63_294 VDD VSS sg13cmos5l_decap_8
X_4985_ _4993_/A _4923_/B _4854_/A _4985_/S VDD VSS sg13cmos5l_mux2_1
XFILLER_51_489 VDD VSS sg13cmos5l_fill_1
X_6724_ _6724_/X _6724_/A _6918_/B VDD VSS sg13cmos5l_and2_1
X_6655_ _6655_/Y _6656_/B _6656_/A VDD VSS sg13cmos5l_nor2_1
X_6586_ _6587_/A _6602_/A _6586_/B VDD VSS sg13cmos5l_nor2_1
X_5606_ _5608_/C _5606_/A _5606_/B VDD VSS sg13cmos5l_nand2_1
X_5537_ _5538_/A _5474_/B _5474_/A _5536_/Y VDD VSS sg13cmos5l_a21o_1
Xbank_A_sram.gen_ihp_256x32.u_sram_256x32_1022 bank_A_sram.gen_ihp_256x32.u_sram_256x32_1022/L_LO
+ VDD VSS sg13cmos5l_tielo
Xbank_A_sram.gen_ihp_256x32.u_sram_256x32_1033 bank_A_sram.gen_ihp_256x32.u_sram_256x32_1033/L_LO
+ VDD VSS sg13cmos5l_tielo
Xbank_A_sram.gen_ihp_256x32.u_sram_256x32_1044 bank_A_sram.gen_ihp_256x32.u_sram_256x32_1044/L_LO
+ VDD VSS sg13cmos5l_tielo
Xbank_A_sram.gen_ihp_256x32.u_sram_256x32_1055 bank_A_sram.gen_ihp_256x32.u_sram_256x32_1055/L_LO
+ VDD VSS sg13cmos5l_tielo
Xbank_A_sram.gen_ihp_256x32.u_sram_256x32_1066 bank_A_sram.gen_ihp_256x32.u_sram_256x32_1066/L_LO
+ VDD VSS sg13cmos5l_tielo
Xbank_A_sram.gen_ihp_256x32.u_sram_256x32_1077 bank_A_sram.gen_ihp_256x32.u_sram_256x32_1077/L_LO
+ VDD VSS sg13cmos5l_tielo
X_7207_ _7207_/Y _6833_/B _7298_/A1 _7297_/A VDD VSS sg13cmos5l_a21oi_1
X_5468_ _5531_/B _5468_/A _5468_/B VDD VSS sg13cmos5l_xor2_1
Xbank_A_sram.gen_ihp_256x32.u_sram_256x32_1088 bank_A_sram.gen_ihp_256x32.u_sram_256x32_1088/L_LO
+ VDD VSS sg13cmos5l_tielo
X_5399_ _5400_/B _5274_/A _5585_/A2 _5205_/A _5585_/B2 VDD VSS sg13cmos5l_a22oi_1
X_4419_ _4421_/A _4494_/A _4492_/A VDD VSS sg13cmos5l_nand2b_1
X_7138_ _7138_/Y _7138_/A _7168_/B VDD VSS sg13cmos5l_nand2_1
XFILLER_87_843 VDD VSS sg13cmos5l_decap_8
XFILLER_47_729 VDD VSS sg13cmos5l_fill_1
XFILLER_59_578 VDD VSS sg13cmos5l_fill_1
X_7069_ _7069_/Y _7069_/A _7069_/B VDD VSS sg13cmos5l_nand2_1
XFILLER_42_401 VDD VSS sg13cmos5l_fill_2
XFILLER_43_913 VDD VSS sg13cmos5l_decap_4
XFILLER_42_434 VDD VSS sg13cmos5l_decap_8
XFILLER_42_445 VDD VSS sg13cmos5l_fill_1
XFILLER_52_87 VDD VSS sg13cmos5l_decap_8
XFILLER_78_821 VDD VSS sg13cmos5l_decap_8
XFILLER_78_898 VDD VSS sg13cmos5l_decap_8
XFILLER_77_375 VDD VSS sg13cmos5l_decap_8
X_4770_ _4771_/B _4646_/A _3951_/A _4588_/A _5017_/B2 VDD VSS sg13cmos5l_a22oi_1
X_6440_ _6441_/A _6440_/A _6548_/D VDD VSS sg13cmos5l_nor2_1
X_6371_ _6373_/A _6372_/A _6372_/C _7669_/Q VDD VSS sg13cmos5l_a21oi_1
X_5322_ _5323_/B _5322_/A1 _5322_/A2 _5385_/A1 _5322_/B2 VDD VSS sg13cmos5l_a22oi_1
XFILLER_47_0 VDD VSS sg13cmos5l_fill_1
X_5253_ _5253_/Y _5253_/A _5213_/B VDD VSS sg13cmos5l_nor2b_1
XFILLER_69_843 VDD VSS sg13cmos5l_decap_8
X_5184_ _5185_/B _5184_/A _5240_/A VDD VSS sg13cmos5l_xnor2_1
X_4204_ _4255_/A _6022_/A _4204_/B VDD VSS sg13cmos5l_xnor2_1
XFILLER_68_353 VDD VSS sg13cmos5l_fill_1
X_4135_ _4136_/B _4135_/A _4135_/B VDD VSS sg13cmos5l_xor2_1
XFILLER_84_835 VDD VSS sg13cmos5l_decap_8
XFILLER_83_323 VDD VSS sg13cmos5l_decap_8
X_4066_ _4108_/C _4068_/A _4068_/B VDD VSS sg13cmos5l_xor2_1
XFILLER_83_356 VDD VSS sg13cmos5l_fill_1
XFILLER_71_529 VDD VSS sg13cmos5l_decap_8
XFILLER_52_787 VDD VSS sg13cmos5l_fill_1
X_4968_ _4970_/A _4968_/A _5302_/A VDD VSS sg13cmos5l_nand2_1
X_7687_ _7687_/Q clkload9/A _7687_/D place754/X VDD VSS sg13cmos5l_dfrbpq_1
X_6707_ _6780_/C _6779_/B VDD VSS sg13cmos5l_inv_1
X_4899_ _4963_/B _4958_/A _4899_/B VDD VSS sg13cmos5l_xnor2_1
X_6638_ _6647_/C _6688_/A _6638_/B VDD VSS sg13cmos5l_nand2_1
X_6569_ _6570_/B _6566_/Y _6579_/A _6552_/C VDD VSS sg13cmos5l_o21ai_1
XFILLER_87_640 VDD VSS sg13cmos5l_decap_8
XFILLER_59_342 VDD VSS sg13cmos5l_decap_8
XFILLER_47_54 VDD VSS sg13cmos5l_fill_2
Xfanout185 _4967_/A _5048_/A VDD VSS sg13cmos5l_buf_1
XFILLER_75_835 VDD VSS sg13cmos5l_decap_8
XFILLER_43_710 VDD VSS sg13cmos5l_decap_4
XFILLER_55_581 VDD VSS sg13cmos5l_fill_1
XFILLER_55_592 VDD VSS sg13cmos5l_fill_2
XFILLER_43_787 VDD VSS sg13cmos5l_decap_8
XFILLER_70_584 VDD VSS sg13cmos5l_decap_4
XFILLER_78_662 VDD VSS sg13cmos5l_decap_8
XFILLER_19_4 VDD VSS sg13cmos5l_decap_8
XFILLER_66_824 VDD VSS sg13cmos5l_decap_8
XFILLER_77_150 VDD VSS sg13cmos5l_fill_1
XFILLER_81_805 VDD VSS sg13cmos5l_decap_8
X_5940_ _5960_/A _5916_/B _5916_/A _5939_/Y VDD VSS sg13cmos5l_a21oi_1
XFILLER_80_337 VDD VSS sg13cmos5l_fill_1
X_5871_ _5872_/B _5901_/B1 _5871_/A2 _5871_/B1 _5871_/B2 VDD VSS sg13cmos5l_a22oi_1
X_7541_ _7545_/C _7614_/B _7614_/A VDD VSS sg13cmos5l_or2_1
X_4753_ _4754_/B _5310_/B1 _4753_/A2 _5244_/B1 _4753_/B2 VDD VSS sg13cmos5l_a22oi_1
X_7472_ _7478_/B _7472_/A1 _7300_/Y _7472_/B1 VDD VSS sg13cmos5l_o21ai_1
X_6423_ _6424_/A _6435_/B _6435_/A VDD VSS sg13cmos5l_nor2_1
X_4684_ _4684_/Y _4684_/A _4654_/B VDD VSS sg13cmos5l_nor2b_1
X_6285_ _6286_/B _7661_/Q _6285_/B VDD VSS sg13cmos5l_xnor2_1
X_5305_ _5305_/Y _5305_/A _5305_/B VDD VSS sg13cmos5l_nor2_1
X_5236_ _7685_/D _5236_/A _5236_/B VDD VSS sg13cmos5l_xnor2_1
XFILLER_124_15 VDD VSS sg13cmos5l_decap_4
XFILLER_69_640 VDD VSS sg13cmos5l_fill_1
XFILLER_56_323 VDD VSS sg13cmos5l_decap_8
XFILLER_57_846 VDD VSS sg13cmos5l_decap_8
XFILLER_68_150 VDD VSS sg13cmos5l_fill_1
X_5167_ _5170_/A _5234_/B _5234_/A VDD VSS sg13cmos5l_xor2_1
XFILLER_84_632 VDD VSS sg13cmos5l_decap_8
XFILLER_56_356 VDD VSS sg13cmos5l_decap_8
X_5098_ _5109_/A _5110_/B _5110_/A VDD VSS sg13cmos5l_xor2_1
X_4118_ _4153_/A _4207_/A _4118_/B VDD VSS sg13cmos5l_xnor2_1
XFILLER_83_131 VDD VSS sg13cmos5l_decap_8
XFILLER_72_816 VDD VSS sg13cmos5l_decap_8
X_4049_ _4072_/A _4049_/A VDD VSS sg13cmos5l_inv_1
XFILLER_71_337 VDD VSS sg13cmos5l_fill_1
XFILLER_71_348 VDD VSS sg13cmos5l_fill_1
XFILLER_80_871 VDD VSS sg13cmos5l_decap_8
XFILLER_123_4 VDD VSS sg13cmos5l_decap_8
XFILLER_47_301 VDD VSS sg13cmos5l_decap_4
XFILLER_48_835 VDD VSS sg13cmos5l_decap_8
XFILLER_58_97 VDD VSS sg13cmos5l_fill_2
Xinput765 input765/X bank_A_wdata[11] VDD VSS sg13cmos5l_buf_1
Xwire1020 wire1020/X wire1020/A VDD VSS sg13cmos5l_buf_2
XFILLER_47_323 VDD VSS sg13cmos5l_decap_8
Xinput776 input776/X bank_A_wdata[21] VDD VSS sg13cmos5l_buf_1
Xinput787 input787/X bank_A_wdata[31] VDD VSS sg13cmos5l_buf_1
Xinput798 _6193_/B bank_B_addr[2] VDD VSS sg13cmos5l_buf_1
XFILLER_75_698 VDD VSS sg13cmos5l_fill_2
XFILLER_75_687 VDD VSS sg13cmos5l_decap_8
XFILLER_43_562 VDD VSS sg13cmos5l_decap_4
XFILLER_62_359 VDD VSS sg13cmos5l_fill_2
XFILLER_70_381 VDD VSS sg13cmos5l_decap_4
XFILLER_71_893 VDD VSS sg13cmos5l_decap_8
Xrebuffer1407 rebuffer1407/X rebuffer1408/X VDD VSS sg13cmos5l_buf_1
Xrebuffer1429 rebuffer1429/X rebuffer1430/X VDD VSS sg13cmos5l_buf_1
Xrebuffer1418 rebuffer1418/X rebuffer1419/X VDD VSS sg13cmos5l_buf_1
X_6070_ _6100_/A _6070_/A _6097_/A VDD VSS sg13cmos5l_xnor2_1
XFILLER_39_813 VDD VSS sg13cmos5l_decap_8
X_5021_ _5022_/B _5058_/A _5021_/B VDD VSS sg13cmos5l_xnor2_1
XFILLER_78_470 VDD VSS sg13cmos5l_fill_1
XFILLER_38_323 VDD VSS sg13cmos5l_decap_8
XFILLER_38_345 VDD VSS sg13cmos5l_decap_4
XFILLER_54_838 VDD VSS sg13cmos5l_decap_8
Xclkbuf_4_11_0_clk_i_regs clkload6/A clkbuf_0_clk_i_regs/X VDD VSS sg13cmos5l_buf_8
XFILLER_81_602 VDD VSS sg13cmos5l_decap_8
XFILLER_53_326 VDD VSS sg13cmos5l_decap_8
XFILLER_65_197 VDD VSS sg13cmos5l_decap_8
X_6972_ _6972_/X _7082_/A _7078_/B VDD VSS sg13cmos5l_and2_1
X_5923_ _5923_/Y _5923_/A _5923_/B VDD VSS sg13cmos5l_nand2_1
XFILLER_81_679 VDD VSS sg13cmos5l_decap_8
XFILLER_61_370 VDD VSS sg13cmos5l_fill_2
X_5854_ _5854_/Y _5854_/A VDD VSS sg13cmos5l_inv_1
X_4805_ _4806_/B _4805_/A _4855_/A VDD VSS sg13cmos5l_xnor2_1
X_7524_ _7526_/A _7524_/A _7524_/B VDD VSS sg13cmos5l_nand2_1
X_5785_ _5787_/A _5786_/A _5786_/B _5786_/C VDD VSS sg13cmos5l_a21oi_1
X_4736_ _4745_/A _4679_/B _4556_/A _4736_/S VDD VSS sg13cmos5l_mux2_1
X_7455_ _7491_/A _7461_/A _7460_/A VDD VSS sg13cmos5l_nand2b_1
X_4667_ _4727_/B _4726_/B _4726_/A VDD VSS sg13cmos5l_xor2_1
X_7386_ _7389_/A _7386_/A _7509_/B _7510_/B VDD VSS sg13cmos5l_nand3_1
X_6406_ _6414_/A _6406_/A _6406_/B VDD VSS sg13cmos5l_nand2_2
X_6337_ _6339_/A _6338_/B _6372_/C _7666_/Q VDD VSS sg13cmos5l_a21oi_1
X_4598_ _4598_/Y _4598_/A VDD VSS sg13cmos5l_inv_1
Xrebuffer1930 rebuffer1930/X rebuffer1931/X VDD VSS sg13cmos5l_buf_1
XFILLER_88_234 VDD VSS sg13cmos5l_decap_4
Xrebuffer1963 rebuffer1963/X _6018_/A VDD VSS sg13cmos5l_buf_1
Xrebuffer1952 rebuffer1952/X rebuffer1953/X VDD VSS sg13cmos5l_buf_1
Xrebuffer1941 rebuffer1941/X rebuffer1942/X VDD VSS sg13cmos5l_buf_1
X_6268_ _6268_/Y _6268_/A _6268_/B _7706_/Q VDD VSS sg13cmos5l_nand3_1
Xrebuffer1996 rebuffer1996/X rebuffer1997/X VDD VSS sg13cmos5l_buf_1
Xrebuffer1985 rebuffer1985/X _5736_/A VDD VSS sg13cmos5l_buf_1
Xrebuffer1974 rebuffer1974/X rebuffer1975/X VDD VSS sg13cmos5l_buf_1
X_6199_ _6199_/Y _6205_/A _6199_/B VDD VSS sg13cmos5l_nor2_1
X_5219_ _5238_/A _5219_/A _5219_/B VDD VSS sg13cmos5l_nand2_1
XFILLER_76_418 VDD VSS sg13cmos5l_fill_2
XFILLER_56_120 VDD VSS sg13cmos5l_fill_2
XFILLER_45_827 VDD VSS sg13cmos5l_decap_8
XFILLER_72_602 VDD VSS sg13cmos5l_fill_2
XFILLER_53_860 VDD VSS sg13cmos5l_decap_8
XFILLER_60_808 VDD VSS sg13cmos5l_fill_1
XFILLER_71_134 VDD VSS sg13cmos5l_decap_8
XFILLER_40_576 VDD VSS sg13cmos5l_fill_1
XFILLER_68_908 VDD VSS sg13cmos5l_decap_8
XFILLER_67_418 VDD VSS sg13cmos5l_decap_4
XFILLER_63_602 VDD VSS sg13cmos5l_decap_8
XFILLER_85_95 VDD VSS sg13cmos5l_fill_1
XFILLER_48_698 VDD VSS sg13cmos5l_fill_2
Xplace602 _5380_/A2 _4930_/A2 VDD VSS sg13cmos5l_buf_1
Xplace613 _4167_/A2 _3996_/Y VDD VSS sg13cmos5l_buf_1
XFILLER_62_134 VDD VSS sg13cmos5l_decap_8
Xplace624 _3976_/B _3960_/Y VDD VSS sg13cmos5l_buf_1
Xplace635 _4434_/B1 _4800_/B1 VDD VSS sg13cmos5l_buf_8
Xplace646 _5805_/B1 _5274_/A VDD VSS sg13cmos5l_buf_1
XFILLER_50_329 VDD VSS sg13cmos5l_decap_8
Xplace657 _5193_/B1 _4646_/A VDD VSS sg13cmos5l_buf_1
Xplace668 _7438_/A _7570_/B VDD VSS sg13cmos5l_buf_1
Xplace679 _7109_/A _6891_/B VDD VSS sg13cmos5l_buf_1
X_5570_ _5571_/B _5859_/B1 _6021_/A2 _5792_/B1 _6021_/B2 VDD VSS sg13cmos5l_a22oi_1
X_4521_ _4534_/A _4643_/A _4521_/B VDD VSS sg13cmos5l_xnor2_1
X_7240_ _7241_/A _7289_/A _7376_/B _7239_/Y VDD VSS sg13cmos5l_o21ai_1
X_4452_ _4453_/B _4518_/A _4518_/B VDD VSS sg13cmos5l_xor2_1
X_7171_ _7171_/Y _6951_/A _7013_/Y _7170_/Y VDD VSS sg13cmos5l_o21ai_1
X_4383_ _4397_/A _4333_/B _4333_/A _4382_/Y VDD VSS sg13cmos5l_a21oi_1
Xrebuffer1248 _6977_/B rebuffer1265/X VDD VSS sg13cmos5l_buf_1
Xrebuffer1259 _7540_/B rebuffer1377/X VDD VSS sg13cmos5l_buf_1
X_6122_ _6135_/B _6144_/A _6122_/B VDD VSS sg13cmos5l_xnor2_1
X_6053_ _6053_/Y _6111_/A _6053_/B VDD VSS sg13cmos5l_nor2_1
XFILLER_86_738 VDD VSS sg13cmos5l_decap_8
XFILLER_39_643 VDD VSS sg13cmos5l_fill_1
X_5004_ _5054_/B _5194_/A _5004_/B VDD VSS sg13cmos5l_xnor2_1
XFILLER_38_142 VDD VSS sg13cmos5l_fill_1
XFILLER_38_153 VDD VSS sg13cmos5l_fill_1
XFILLER_53_123 VDD VSS sg13cmos5l_decap_8
XFILLER_54_657 VDD VSS sg13cmos5l_fill_2
X_6955_ _6955_/Y _6955_/A _6955_/B VDD VSS sg13cmos5l_nand2_1
X_5906_ _5947_/B _5906_/A _5906_/B VDD VSS sg13cmos5l_xnor2_1
XFILLER_50_841 VDD VSS sg13cmos5l_decap_8
X_6886_ _6886_/Y _6886_/A _7071_/B VDD VSS sg13cmos5l_nand2_1
X_5837_ _5838_/B _5837_/A _5837_/B _5837_/C VDD VSS sg13cmos5l_nand3_1
X_5768_ _5822_/A _5768_/A _5768_/B VDD VSS sg13cmos5l_xnor2_1
X_7507_ _7508_/B _7564_/B _7507_/B VDD VSS sg13cmos5l_nand2_1
X_4719_ _4730_/A _4660_/B _4660_/A _4718_/Y VDD VSS sg13cmos5l_a21o_1
X_7438_ _7583_/A _7438_/A _7585_/B VDD VSS sg13cmos5l_xnor2_1
X_5699_ _5700_/B _6082_/B1 _5869_/A2 _6058_/B1 _5869_/B2 VDD VSS sg13cmos5l_a22oi_1
X_7369_ _7370_/A _7369_/A _7369_/B VDD VSS sg13cmos5l_nor2_1
XFILLER_39_44 VDD VSS sg13cmos5l_decap_8
XFILLER_85_793 VDD VSS sg13cmos5l_decap_8
XFILLER_60_605 VDD VSS sg13cmos5l_fill_2
XFILLER_44_189 VDD VSS sg13cmos5l_decap_4
XFILLER_41_852 VDD VSS sg13cmos5l_decap_8
XFILLER_71_42 VDD VSS sg13cmos5l_fill_2
XFILLER_71_64 VDD VSS sg13cmos5l_fill_1
XFILLER_64_911 VDD VSS sg13cmos5l_decap_8
XFILLER_83_719 VDD VSS sg13cmos5l_decap_8
XFILLER_51_627 VDD VSS sg13cmos5l_decap_8
XFILLER_51_638 VDD VSS sg13cmos5l_fill_2
XFILLER_63_476 VDD VSS sg13cmos5l_fill_1
X_6740_ _6740_/Y _6740_/A1 _6733_/B _6661_/B VDD VSS sg13cmos5l_a21oi_1
X_3952_ _4422_/A _3999_/B VDD VSS sg13cmos5l_inv_1
X_6671_ _6681_/C _6688_/A _6671_/B VDD VSS sg13cmos5l_nand2_1
X_5622_ _5682_/S _5684_/B1 _6136_/A _5622_/B1 _4496_/Y VDD VSS sg13cmos5l_a22oi_1
X_5553_ _7690_/D _5553_/A _5616_/A VDD VSS sg13cmos5l_nor2b_1
X_4504_ _4505_/B _4502_/Y _4504_/B VDD VSS sg13cmos5l_nand2b_1
Xbank_A_sram.gen_ihp_256x32.u_sram_256x32_1204 bank_A_sram.gen_ihp_256x32.u_sram_256x32/A_BM[29]
+ VDD VSS sg13cmos5l_tiehi
X_5484_ _5488_/A _5489_/C _5552_/B VDD VSS sg13cmos5l_nand2_1
X_7223_ _7223_/Y _7298_/A1 _6953_/A _7222_/Y VDD VSS sg13cmos5l_o21ai_1
X_4435_ _4500_/A _4871_/A _4435_/B VDD VSS sg13cmos5l_xnor2_1
Xoutput866 act_out[5] _6224_/Y VDD VSS sg13cmos5l_buf_1
Xoutput877 bank_A_rdata[17] wire1005/A VDD VSS sg13cmos5l_buf_1
Xoutput888 bank_A_rdata[27] wire993/A VDD VSS sg13cmos5l_buf_1
X_7154_ _7154_/Y _7154_/A _7178_/S VDD VSS sg13cmos5l_nand2_1
Xoutput899 bank_A_rdata[8] _4127_/A VDD VSS sg13cmos5l_buf_1
X_6105_ _7702_/D _6105_/A _6105_/B VDD VSS sg13cmos5l_xor2_1
XFILLER_86_524 VDD VSS sg13cmos5l_decap_8
Xbank_B_sram.gen_ihp_256x32.u_sram_256x32_1213 bank_B_sram.gen_ihp_256x32.u_sram_256x32/A_BM[4]
+ VDD VSS sg13cmos5l_tiehi
X_7085_ _7085_/Y _7085_/A _7085_/B VDD VSS sg13cmos5l_nand2_1
X_4297_ _4297_/X _4297_/A _4297_/B VDD VSS sg13cmos5l_and2_1
XFILLER_67_760 VDD VSS sg13cmos5l_decap_8
XFILLER_67_771 VDD VSS sg13cmos5l_fill_1
XFILLER_73_207 VDD VSS sg13cmos5l_decap_4
Xbank_B_sram.gen_ihp_256x32.u_sram_256x32_1224 bank_B_sram.gen_ihp_256x32.u_sram_256x32/A_BM[15]
+ VDD VSS sg13cmos5l_tiehi
Xbank_B_sram.gen_ihp_256x32.u_sram_256x32_1235 bank_B_sram.gen_ihp_256x32.u_sram_256x32/A_BM[26]
+ VDD VSS sg13cmos5l_tiehi
X_6036_ _6036_/Y _6036_/A VDD VSS sg13cmos5l_inv_1
XFILLER_54_443 VDD VSS sg13cmos5l_fill_2
XFILLER_70_903 VDD VSS sg13cmos5l_decap_8
XFILLER_82_741 VDD VSS sg13cmos5l_decap_8
XFILLER_81_240 VDD VSS sg13cmos5l_decap_8
XFILLER_42_605 VDD VSS sg13cmos5l_fill_1
X_6938_ _6938_/Y _6932_/Y _7164_/A _6937_/Y VDD VSS sg13cmos5l_a21oi_2
X_6869_ _6871_/A _6869_/A _6869_/B VDD VSS sg13cmos5l_nand2_1
XFILLER_41_89 VDD VSS sg13cmos5l_fill_1
XFILLER_49_237 VDD VSS sg13cmos5l_fill_1
XFILLER_77_535 VDD VSS sg13cmos5l_decap_8
XFILLER_46_911 VDD VSS sg13cmos5l_decap_8
XFILLER_66_31 VDD VSS sg13cmos5l_decap_4
XFILLER_58_793 VDD VSS sg13cmos5l_decap_4
XFILLER_85_590 VDD VSS sg13cmos5l_decap_8
XFILLER_73_752 VDD VSS sg13cmos5l_fill_1
XFILLER_61_914 VDD VSS sg13cmos5l_decap_4
XFILLER_72_273 VDD VSS sg13cmos5l_decap_8
XFILLER_73_796 VDD VSS sg13cmos5l_decap_8
X_4220_ _4220_/Y _4220_/A _4220_/B VDD VSS sg13cmos5l_nor2_1
X_4082_ _4092_/A _4168_/A _4082_/B VDD VSS sg13cmos5l_xnor2_1
XFILLER_49_782 VDD VSS sg13cmos5l_decap_8
XFILLER_55_218 VDD VSS sg13cmos5l_fill_2
XFILLER_76_590 VDD VSS sg13cmos5l_decap_8
XFILLER_51_402 VDD VSS sg13cmos5l_decap_8
X_4984_ _5029_/A _5048_/A _5045_/B VDD VSS sg13cmos5l_xnor2_1
XFILLER_51_479 VDD VSS sg13cmos5l_fill_2
X_6723_ _6724_/A _6722_/Y _6723_/B VDD VSS sg13cmos5l_nand2b_1
X_3935_ _7659_/D _3935_/A VDD VSS sg13cmos5l_inv_1
X_6654_ _6656_/B _6688_/A _6654_/B VDD VSS sg13cmos5l_nand2_1
X_5605_ _5608_/A _5667_/B VDD VSS sg13cmos5l_inv_1
X_6585_ _6765_/B _6585_/A _6585_/B VDD VSS sg13cmos5l_nand2_2
X_5536_ _5536_/Y _5536_/A _5475_/B VDD VSS sg13cmos5l_nor2b_1
Xbank_A_sram.gen_ihp_256x32.u_sram_256x32_1023 bank_A_sram.gen_ihp_256x32.u_sram_256x32_1023/L_LO
+ VDD VSS sg13cmos5l_tielo
Xbank_A_sram.gen_ihp_256x32.u_sram_256x32_1034 bank_A_sram.gen_ihp_256x32.u_sram_256x32_1034/L_LO
+ VDD VSS sg13cmos5l_tielo
X_5467_ _5468_/B _5501_/A _5467_/B VDD VSS sg13cmos5l_xnor2_1
Xbank_A_sram.gen_ihp_256x32.u_sram_256x32_1045 bank_A_sram.gen_ihp_256x32.u_sram_256x32_1045/L_LO
+ VDD VSS sg13cmos5l_tielo
Xbank_A_sram.gen_ihp_256x32.u_sram_256x32_1056 bank_A_sram.gen_ihp_256x32.u_sram_256x32_1056/L_LO
+ VDD VSS sg13cmos5l_tielo
Xbank_A_sram.gen_ihp_256x32.u_sram_256x32_1067 bank_A_sram.gen_ihp_256x32.u_sram_256x32_1067/L_LO
+ VDD VSS sg13cmos5l_tielo
Xbank_A_sram.gen_ihp_256x32.u_sram_256x32_1078 bank_A_sram.gen_ihp_256x32.u_sram_256x32_1078/L_LO
+ VDD VSS sg13cmos5l_tielo
X_7206_ _7362_/B _6776_/X _7276_/S _7205_/Y VDD VSS sg13cmos5l_a21oi_1
X_4418_ _4483_/A _4418_/A _4418_/B VDD VSS sg13cmos5l_and2_1
Xbank_A_sram.gen_ihp_256x32.u_sram_256x32_1089 bank_A_sram.gen_ihp_256x32.u_sram_256x32_1089/L_LO
+ VDD VSS sg13cmos5l_tielo
X_5398_ _5453_/A _5460_/B _5641_/B1 _5397_/Y VDD VSS sg13cmos5l_a21o_1
XFILLER_87_822 VDD VSS sg13cmos5l_decap_8
X_7137_ _7137_/Y _7294_/A _7277_/B _7136_/X VDD VSS sg13cmos5l_a21oi_1
X_4349_ _4349_/Y _4411_/B _4349_/B VDD VSS sg13cmos5l_xnor2_1
X_7068_ _7068_/Y _7063_/Y _7134_/B _7067_/Y VDD VSS sg13cmos5l_a21oi_1
XFILLER_87_899 VDD VSS sg13cmos5l_decap_8
XFILLER_36_12 VDD VSS sg13cmos5l_decap_8
X_6019_ _6019_/Y _6019_/A _5992_/A VDD VSS sg13cmos5l_nor2b_1
XFILLER_55_741 VDD VSS sg13cmos5l_fill_1
XFILLER_67_590 VDD VSS sg13cmos5l_fill_1
Xbank_B_sram.gen_ihp_256x32.u_sram_256x32_1098 bank_B_sram.gen_ihp_256x32.u_sram_256x32_1098/L_LO
+ VDD VSS sg13cmos5l_tielo
XFILLER_54_251 VDD VSS sg13cmos5l_decap_4
XFILLER_70_755 VDD VSS sg13cmos5l_decap_8
XFILLER_52_22 VDD VSS sg13cmos5l_fill_2
XFILLER_52_55 VDD VSS sg13cmos5l_fill_2
XFILLER_78_800 VDD VSS sg13cmos5l_decap_8
XFILLER_78_877 VDD VSS sg13cmos5l_decap_8
XFILLER_77_96 VDD VSS sg13cmos5l_fill_2
XFILLER_77_85 VDD VSS sg13cmos5l_decap_8
XFILLER_46_730 VDD VSS sg13cmos5l_fill_2
XFILLER_45_240 VDD VSS sg13cmos5l_decap_8
XFILLER_45_251 VDD VSS sg13cmos5l_fill_1
XFILLER_46_774 VDD VSS sg13cmos5l_fill_1
XFILLER_73_571 VDD VSS sg13cmos5l_fill_1
XFILLER_61_755 VDD VSS sg13cmos5l_fill_1
XFILLER_61_766 VDD VSS sg13cmos5l_decap_8
X_6370_ _6372_/A _6367_/Y _6379_/A VDD VSS sg13cmos5l_nand2b_1
X_5321_ _5327_/A _5381_/A _5321_/B VDD VSS sg13cmos5l_xnor2_1
X_5252_ _5346_/A _5252_/A _5252_/B VDD VSS sg13cmos5l_xor2_1
XFILLER_69_822 VDD VSS sg13cmos5l_decap_8
X_5183_ _5240_/A _5137_/B _5137_/A _5182_/X VDD VSS sg13cmos5l_a21oi_1
X_4203_ _4204_/B _4203_/A _4303_/B VDD VSS sg13cmos5l_nand2_1
X_4134_ _4135_/A _4134_/A _4134_/B VDD VSS sg13cmos5l_xor2_1
XFILLER_84_814 VDD VSS sg13cmos5l_decap_8
XFILLER_69_899 VDD VSS sg13cmos5l_decap_8
X_4065_ _4068_/B _4072_/A _4065_/B VDD VSS sg13cmos5l_xnor2_1
XFILLER_64_571 VDD VSS sg13cmos5l_fill_1
XFILLER_83_368 VDD VSS sg13cmos5l_decap_4
XFILLER_51_221 VDD VSS sg13cmos5l_fill_1
XFILLER_52_744 VDD VSS sg13cmos5l_fill_1
XFILLER_51_254 VDD VSS sg13cmos5l_decap_4
XFILLER_52_766 VDD VSS sg13cmos5l_decap_8
X_4967_ _5242_/A _4967_/A VDD VSS sg13cmos5l_buf_1
X_7686_ _7686_/Q _7704_/CLK _7686_/D place754/X VDD VSS sg13cmos5l_dfrbpq_1
X_6706_ _6779_/B _6696_/Y _6702_/Y _6705_/Y VDD VSS sg13cmos5l_a21oi_1
X_4898_ _4899_/B _4898_/A _4959_/B VDD VSS sg13cmos5l_xor2_1
X_6637_ _6732_/B _6637_/A _6637_/B VDD VSS sg13cmos5l_nand2_2
X_5519_ _5520_/A _5519_/A _5519_/B VDD VSS sg13cmos5l_nand2_1
XFILLER_98_18 VDD VSS sg13cmos5l_fill_2
X_6499_ _6508_/B _6541_/A _6979_/B _6499_/C _6978_/B VDD VSS sg13cmos5l_nand4_1
XFILLER_0_7 VDD VSS sg13cmos5l_decap_8
XFILLER_75_814 VDD VSS sg13cmos5l_decap_8
XFILLER_47_33 VDD VSS sg13cmos5l_fill_2
Xfanout197 _4207_/A _4312_/A VDD VSS sg13cmos5l_buf_1
XFILLER_87_696 VDD VSS sg13cmos5l_decap_8
XFILLER_47_88 VDD VSS sg13cmos5l_fill_1
XFILLER_74_357 VDD VSS sg13cmos5l_fill_2
XFILLER_83_880 VDD VSS sg13cmos5l_decap_8
XFILLER_63_76 VDD VSS sg13cmos5l_decap_8
XFILLER_63_87 VDD VSS sg13cmos5l_fill_1
XFILLER_69_107 VDD VSS sg13cmos5l_decap_4
X_5870_ _5913_/A _5870_/A _5870_/B VDD VSS sg13cmos5l_xnor2_1
XFILLER_80_327 VDD VSS sg13cmos5l_fill_2
XFILLER_73_390 VDD VSS sg13cmos5l_decap_8
X_4821_ _4832_/A _5141_/A _4821_/B VDD VSS sg13cmos5l_xnor2_1
X_7540_ _7614_/A _7539_/Y _7540_/B VDD VSS sg13cmos5l_nand2b_1
X_4683_ _4778_/B _4683_/A _4683_/B VDD VSS sg13cmos5l_xor2_1
X_6422_ _6435_/A _6431_/A _6421_/Y _6450_/A2 VDD VSS sg13cmos5l_o21ai_1
X_6284_ _6285_/B _6284_/A _6328_/C VDD VSS sg13cmos5l_nand2_2
X_5304_ _5363_/B _5546_/A _5304_/B VDD VSS sg13cmos5l_nor2_1
X_5235_ _5298_/A _5169_/Y _5170_/A _5234_/X VDD VSS sg13cmos5l_a21o_1
XFILLER_69_663 VDD VSS sg13cmos5l_fill_2
XFILLER_57_825 VDD VSS sg13cmos5l_decap_8
XFILLER_69_674 VDD VSS sg13cmos5l_decap_8
X_5166_ _5234_/A _5228_/A _5229_/A VDD VSS sg13cmos5l_xor2_1
XFILLER_84_611 VDD VSS sg13cmos5l_decap_8
XFILLER_68_184 VDD VSS sg13cmos5l_fill_1
X_5097_ _5110_/A _5029_/B _5029_/A _5096_/X VDD VSS sg13cmos5l_a21o_1
X_4117_ _4118_/B _3964_/C _4048_/A _4162_/A1 _4311_/B2 VDD VSS sg13cmos5l_a22oi_1
X_4048_ _4049_/A _4048_/A _4303_/B VDD VSS sg13cmos5l_nand2_1
XFILLER_84_688 VDD VSS sg13cmos5l_decap_8
XFILLER_80_850 VDD VSS sg13cmos5l_decap_8
X_5999_ _5999_/Y _5999_/A _5999_/B VDD VSS sg13cmos5l_nand2_1
X_7669_ _7669_/Q clkload4/A _7669_/D place746/X VDD VSS sg13cmos5l_dfrbpq_1
XFILLER_79_416 VDD VSS sg13cmos5l_decap_4
XFILLER_48_803 VDD VSS sg13cmos5l_fill_2
XFILLER_48_814 VDD VSS sg13cmos5l_decap_8
XFILLER_59_173 VDD VSS sg13cmos5l_fill_2
Xinput755 input755/X bank_A_addr[0] VDD VSS sg13cmos5l_buf_1
Xwire1010 _4762_/B1 wire1010/A VDD VSS sg13cmos5l_buf_2
XFILLER_87_482 VDD VSS sg13cmos5l_fill_2
XFILLER_75_611 VDD VSS sg13cmos5l_decap_8
XFILLER_59_195 VDD VSS sg13cmos5l_fill_1
Xinput766 input766/X bank_A_wdata[12] VDD VSS sg13cmos5l_buf_1
Xinput777 input777/X bank_A_wdata[22] VDD VSS sg13cmos5l_buf_1
Xinput788 input788/X bank_A_wdata[3] VDD VSS sg13cmos5l_buf_1
XFILLER_75_644 VDD VSS sg13cmos5l_decap_4
XFILLER_74_165 VDD VSS sg13cmos5l_decap_8
Xinput799 _6196_/B bank_B_addr[3] VDD VSS sg13cmos5l_buf_1
XFILLER_75_666 VDD VSS sg13cmos5l_decap_8
XFILLER_62_327 VDD VSS sg13cmos5l_fill_2
XFILLER_74_176 VDD VSS sg13cmos5l_fill_1
XFILLER_71_872 VDD VSS sg13cmos5l_decap_8
Xrebuffer1408 rebuffer1408/X rebuffer1409/X VDD VSS sg13cmos5l_buf_1
Xrebuffer1419 rebuffer1419/X rebuffer1420/X VDD VSS sg13cmos5l_buf_1
X_5020_ _5021_/B _5020_/A _5020_/B VDD VSS sg13cmos5l_xor2_1
XFILLER_39_869 VDD VSS sg13cmos5l_decap_8
XFILLER_38_379 VDD VSS sg13cmos5l_fill_1
X_6971_ _7082_/A _6974_/B _6788_/A _6970_/Y VDD VSS sg13cmos5l_o21ai_1
XFILLER_80_102 VDD VSS sg13cmos5l_decap_8
X_5922_ _5922_/Y _5922_/A VDD VSS sg13cmos5l_inv_1
XFILLER_81_658 VDD VSS sg13cmos5l_decap_8
XFILLER_62_894 VDD VSS sg13cmos5l_decap_8
X_5853_ _5881_/A _5800_/B _5800_/A _5852_/Y VDD VSS sg13cmos5l_a21oi_1
XFILLER_80_179 VDD VSS sg13cmos5l_decap_8
X_5784_ _5786_/C _5845_/B _5845_/A VDD VSS sg13cmos5l_xor2_1
X_4804_ _4855_/A _4758_/B _4758_/A _4803_/X VDD VSS sg13cmos5l_a21oi_1
X_7523_ _7618_/D _7523_/A _7519_/A VDD VSS sg13cmos5l_nor2b_1
X_4735_ _4794_/A _4683_/B _4683_/A _4734_/Y VDD VSS sg13cmos5l_a21oi_1
X_7454_ _7461_/A _7226_/Y _7397_/A _7399_/A VDD VSS sg13cmos5l_a21o_1
X_4666_ _4726_/A _4671_/A _4671_/B VDD VSS sg13cmos5l_xor2_1
X_7385_ _7510_/B _7385_/A _7570_/B VDD VSS sg13cmos5l_nand2_1
X_6405_ _6406_/B _6403_/B _7672_/Q VDD VSS sg13cmos5l_nand2b_1
X_4597_ _4658_/B _4597_/A _4597_/B VDD VSS sg13cmos5l_xor2_1
X_6336_ _6338_/B _6336_/A _6342_/B VDD VSS sg13cmos5l_xor2_1
Xrebuffer1920 rebuffer1920/X rebuffer1921/X VDD VSS sg13cmos5l_buf_1
Xrebuffer1964 rebuffer1964/X rebuffer1965/X VDD VSS sg13cmos5l_buf_1
Xrebuffer1953 rebuffer1953/X rebuffer1954/X VDD VSS sg13cmos5l_buf_1
Xrebuffer1942 rebuffer1942/X rebuffer1943/X VDD VSS sg13cmos5l_buf_1
Xrebuffer1931 rebuffer1931/X rebuffer1932/X VDD VSS sg13cmos5l_buf_1
X_6267_ _6270_/A _6267_/A _6267_/B VDD VSS sg13cmos5l_nand2_1
XFILLER_88_257 VDD VSS sg13cmos5l_decap_4
Xrebuffer1997 rebuffer1997/X _6077_/A VDD VSS sg13cmos5l_buf_1
Xrebuffer1986 _6047_/B_N rebuffer1987/X VDD VSS sg13cmos5l_buf_1
Xrebuffer1975 rebuffer1975/X rebuffer1976/X VDD VSS sg13cmos5l_buf_1
X_6198_ _6198_/Y _6198_/A VDD VSS sg13cmos5l_inv_1
X_5218_ _5219_/B _5155_/A _5218_/B VDD VSS sg13cmos5l_nand2b_1
X_5149_ _5150_/B _5013_/A _5585_/A2 _4946_/A _5585_/B2 VDD VSS sg13cmos5l_a22oi_1
XFILLER_45_806 VDD VSS sg13cmos5l_decap_8
XFILLER_38_891 VDD VSS sg13cmos5l_decap_8
XFILLER_71_113 VDD VSS sg13cmos5l_decap_8
XFILLER_72_636 VDD VSS sg13cmos5l_fill_1
XFILLER_84_485 VDD VSS sg13cmos5l_fill_2
XFILLER_40_511 VDD VSS sg13cmos5l_fill_1
XFILLER_71_179 VDD VSS sg13cmos5l_decap_8
XFILLER_52_382 VDD VSS sg13cmos5l_decap_8
XFILLER_80_691 VDD VSS sg13cmos5l_decap_8
XFILLER_60_88 VDD VSS sg13cmos5l_decap_8
XFILLER_69_86 VDD VSS sg13cmos5l_decap_8
XFILLER_88_780 VDD VSS sg13cmos5l_decap_4
XFILLER_48_622 VDD VSS sg13cmos5l_fill_1
XFILLER_48_633 VDD VSS sg13cmos5l_fill_2
XFILLER_47_143 VDD VSS sg13cmos5l_fill_1
XFILLER_48_677 VDD VSS sg13cmos5l_fill_1
XFILLER_63_647 VDD VSS sg13cmos5l_decap_8
Xplace603 _4930_/A2 _4203_/A VDD VSS sg13cmos5l_buf_1
Xplace614 _6175_/B _5966_/A VDD VSS sg13cmos5l_buf_1
XFILLER_62_124 VDD VSS sg13cmos5l_fill_2
XFILLER_62_157 VDD VSS sg13cmos5l_fill_1
Xplace625 _4947_/B _4767_/B VDD VSS sg13cmos5l_buf_1
Xplace636 _4920_/B1 _4085_/A VDD VSS sg13cmos5l_buf_4
Xplace647 _5801_/A1 _5205_/A VDD VSS sg13cmos5l_buf_1
XFILLER_44_883 VDD VSS sg13cmos5l_decap_8
Xplace658 _5066_/A1 _4588_/A VDD VSS sg13cmos5l_buf_1
Xplace669 _7570_/B _7360_/B VDD VSS sg13cmos5l_buf_1
XFILLER_71_691 VDD VSS sg13cmos5l_decap_4
X_4520_ _4521_/B _4583_/B1 _3999_/A _4520_/B1 _4642_/B2 VDD VSS sg13cmos5l_a22oi_1
X_4451_ _4518_/B _4532_/A _4451_/B VDD VSS sg13cmos5l_xnor2_1
X_7170_ _7170_/Y _7170_/A _7184_/B VDD VSS sg13cmos5l_nand2_1
X_6121_ _6122_/B _6145_/A _6145_/B VDD VSS sg13cmos5l_xor2_1
X_4382_ _4382_/Y _4382_/A _4382_/B VDD VSS sg13cmos5l_nor2_1
Xrebuffer1249 _6376_/A rebuffer1265/X VDD VSS sg13cmos5l_buf_1
XFILLER_39_600 VDD VSS sg13cmos5l_fill_1
X_6052_ _6052_/Y _6052_/A _6052_/B VDD VSS sg13cmos5l_nand2_1
XFILLER_86_717 VDD VSS sg13cmos5l_decap_8
XFILLER_39_622 VDD VSS sg13cmos5l_fill_1
X_5003_ _5004_/B _5066_/B1 _5385_/A2 _5370_/B1 _5385_/B2 VDD VSS sg13cmos5l_a22oi_1
XFILLER_79_791 VDD VSS sg13cmos5l_decap_8
XFILLER_66_463 VDD VSS sg13cmos5l_fill_2
XFILLER_53_102 VDD VSS sg13cmos5l_decap_8
XFILLER_42_809 VDD VSS sg13cmos5l_decap_8
XFILLER_53_135 VDD VSS sg13cmos5l_decap_8
X_6954_ _6954_/Y _6938_/Y _6891_/B _6953_/X VDD VSS sg13cmos5l_a21oi_2
XFILLER_81_433 VDD VSS sg13cmos5l_fill_1
X_5905_ _5906_/B _5903_/Y _5905_/B VDD VSS sg13cmos5l_nand2b_1
XFILLER_14_15 VDD VSS sg13cmos5l_decap_4
XFILLER_50_820 VDD VSS sg13cmos5l_decap_8
XFILLER_62_691 VDD VSS sg13cmos5l_fill_2
X_6885_ _6886_/A _6927_/B _6882_/Y _6884_/Y VDD VSS sg13cmos5l_o21ai_1
X_5836_ _5838_/A _5837_/B _5837_/C _5837_/A VDD VSS sg13cmos5l_a21o_1
XFILLER_50_897 VDD VSS sg13cmos5l_decap_8
X_5767_ _5768_/B _5767_/A _5767_/B VDD VSS sg13cmos5l_xor2_1
X_7506_ _7508_/A _7506_/A _7506_/B VDD VSS sg13cmos5l_nand2_1
X_4718_ _4718_/Y _4718_/A _4661_/B VDD VSS sg13cmos5l_nor2b_1
X_7437_ _7585_/B _7472_/A1 _7110_/Y _7472_/B1 VDD VSS sg13cmos5l_o21ai_1
X_4649_ _4695_/A _4767_/B _4588_/A _4648_/Y VDD VSS sg13cmos5l_a21o_1
X_7368_ _7375_/A _7368_/A _7368_/B _7513_/A VDD VSS sg13cmos5l_nand3_1
XFILLER_39_23 VDD VSS sg13cmos5l_decap_8
X_7299_ _7299_/Y _7299_/A1 _7295_/Y _7298_/Y VDD VSS sg13cmos5l_o21ai_1
X_6319_ _6320_/A _6319_/A _6787_/A VDD VSS sg13cmos5l_nand2_2
XFILLER_73_901 VDD VSS sg13cmos5l_decap_8
XFILLER_85_772 VDD VSS sg13cmos5l_decap_8
XFILLER_57_496 VDD VSS sg13cmos5l_fill_2
XFILLER_72_422 VDD VSS sg13cmos5l_fill_2
XFILLER_84_271 VDD VSS sg13cmos5l_fill_2
XFILLER_45_647 VDD VSS sg13cmos5l_decap_4
XFILLER_55_66 VDD VSS sg13cmos5l_decap_8
XFILLER_84_293 VDD VSS sg13cmos5l_decap_4
XFILLER_44_157 VDD VSS sg13cmos5l_decap_4
XFILLER_41_831 VDD VSS sg13cmos5l_decap_8
XFILLER_40_341 VDD VSS sg13cmos5l_fill_1
XFILLER_40_385 VDD VSS sg13cmos5l_fill_2
XFILLER_67_216 VDD VSS sg13cmos5l_decap_4
XFILLER_67_238 VDD VSS sg13cmos5l_fill_2
XFILLER_48_463 VDD VSS sg13cmos5l_fill_2
XFILLER_51_606 VDD VSS sg13cmos5l_decap_8
X_3951_ _3970_/A _3951_/A _4303_/B VDD VSS sg13cmos5l_nand2_1
XFILLER_50_116 VDD VSS sg13cmos5l_decap_8
XFILLER_50_149 VDD VSS sg13cmos5l_decap_8
X_6670_ _6677_/A _6670_/A _6742_/A _6743_/B VDD VSS sg13cmos5l_nand3_1
X_5621_ _5629_/A _5560_/B _5302_/A _5621_/S VDD VSS sg13cmos5l_mux2_1
X_5552_ _5618_/A _5552_/A _5552_/B _5552_/C VDD VSS sg13cmos5l_nand3_1
X_4503_ _4504_/B _4503_/A _4503_/B VDD VSS sg13cmos5l_nand2_1
Xbank_A_sram.gen_ihp_256x32.u_sram_256x32_1205 bank_A_sram.gen_ihp_256x32.u_sram_256x32/A_BM[30]
+ VDD VSS sg13cmos5l_tiehi
X_5483_ _5552_/B _5482_/B _5483_/B VDD VSS sg13cmos5l_nand2b_1
X_7222_ _7222_/Y _7297_/A _7222_/B VDD VSS sg13cmos5l_nor2_1
X_4434_ _4435_/B wire977/X _4753_/A2 _4434_/B1 _4753_/B2 VDD VSS sg13cmos5l_a22oi_1
Xoutput867 act_out[6] _6226_/Y VDD VSS sg13cmos5l_buf_1
Xoutput878 bank_A_rdata[18] wire1004/A VDD VSS sg13cmos5l_buf_1
X_4365_ _4365_/Y _6110_/B _6110_/A _4364_/Y VDD VSS sg13cmos5l_o21ai_1
Xoutput889 bank_A_rdata[28] _5334_/A VDD VSS sg13cmos5l_buf_1
X_7084_ _7084_/Y _7082_/Y _7083_/Y _6321_/B VDD VSS sg13cmos5l_a21oi_1
X_6104_ _6105_/B _6078_/B _6078_/A _6103_/X VDD VSS sg13cmos5l_a21o_1
XFILLER_86_503 VDD VSS sg13cmos5l_decap_8
X_6035_ _6039_/A _6067_/A _6035_/B VDD VSS sg13cmos5l_xnor2_1
X_4296_ _4343_/B _4296_/A _4296_/B VDD VSS sg13cmos5l_nand2_1
Xbank_B_sram.gen_ihp_256x32.u_sram_256x32_1214 bank_B_sram.gen_ihp_256x32.u_sram_256x32/A_BM[5]
+ VDD VSS sg13cmos5l_tiehi
Xbank_B_sram.gen_ihp_256x32.u_sram_256x32_1225 bank_B_sram.gen_ihp_256x32.u_sram_256x32/A_BM[16]
+ VDD VSS sg13cmos5l_tiehi
Xbank_B_sram.gen_ihp_256x32.u_sram_256x32_1236 bank_B_sram.gen_ihp_256x32.u_sram_256x32/A_BM[27]
+ VDD VSS sg13cmos5l_tiehi
XFILLER_39_474 VDD VSS sg13cmos5l_decap_8
XFILLER_39_485 VDD VSS sg13cmos5l_fill_2
XFILLER_67_783 VDD VSS sg13cmos5l_decap_8
XFILLER_82_720 VDD VSS sg13cmos5l_decap_8
XFILLER_41_105 VDD VSS sg13cmos5l_decap_8
XFILLER_82_797 VDD VSS sg13cmos5l_decap_8
XFILLER_41_138 VDD VSS sg13cmos5l_fill_2
X_6937_ _6937_/Y _7164_/A _7134_/A VDD VSS sg13cmos5l_nor2_1
XFILLER_81_296 VDD VSS sg13cmos5l_decap_8
XFILLER_50_661 VDD VSS sg13cmos5l_decap_8
X_6868_ _6877_/A _7029_/A _7069_/B VDD VSS sg13cmos5l_nand2_1
X_5819_ _5820_/B _5855_/B _5855_/A VDD VSS sg13cmos5l_xnor2_1
X_6799_ _6800_/B _6799_/A _6799_/B VDD VSS sg13cmos5l_xor2_1
XFILLER_41_68 VDD VSS sg13cmos5l_decap_4
XFILLER_49_216 VDD VSS sg13cmos5l_decap_8
XFILLER_49_249 VDD VSS sg13cmos5l_decap_8
XFILLER_58_772 VDD VSS sg13cmos5l_decap_8
XFILLER_40_182 VDD VSS sg13cmos5l_decap_4
X_4150_ _4266_/A quant_cfg[9] VDD VSS sg13cmos5l_buf_1
XFILLER_68_558 VDD VSS sg13cmos5l_fill_2
X_4081_ _4082_/B _4156_/A1 _4167_/A2 wire989/X _4271_/B2 VDD VSS sg13cmos5l_a22oi_1
XFILLER_48_293 VDD VSS sg13cmos5l_fill_1
XFILLER_52_915 VDD VSS sg13cmos5l_fill_2
XFILLER_63_252 VDD VSS sg13cmos5l_decap_8
XFILLER_51_425 VDD VSS sg13cmos5l_fill_2
X_4983_ _5045_/B _4927_/B _4927_/A _4982_/Y VDD VSS sg13cmos5l_a21oi_1
Xbank_B_sram.gen_ihp_256x32.u_sram_256x32 input811/X input810/X bank_B_sram.gen_ihp_256x32.u_sram_256x32_1155/L_LO
+ bank_B_sram.gen_ihp_256x32.u_sram_256x32_1154/L_LO bank_B_sram.gen_ihp_256x32.u_sram_256x32/A_BM[16]
+ bank_B_sram.gen_ihp_256x32.u_sram_256x32/A_BM[15] bank_B_sram.gen_ihp_256x32.u_sram_256x32_1122/L_LO
+ bank_B_sram.gen_ihp_256x32.u_sram_256x32_1121/L_LO output908/A output907/A VSS VDD
+ VDD input812/X input809/X bank_B_sram.gen_ihp_256x32.u_sram_256x32_1156/L_LO bank_B_sram.gen_ihp_256x32.u_sram_256x32_1153/L_LO
+ bank_B_sram.gen_ihp_256x32.u_sram_256x32/A_BM[17] bank_B_sram.gen_ihp_256x32.u_sram_256x32/A_BM[14]
+ bank_B_sram.gen_ihp_256x32.u_sram_256x32_1123/L_LO bank_B_sram.gen_ihp_256x32.u_sram_256x32_1120/L_LO
+ output909/A output906/A input813/X input808/X bank_B_sram.gen_ihp_256x32.u_sram_256x32_1157/L_LO
+ bank_B_sram.gen_ihp_256x32.u_sram_256x32_1152/L_LO bank_B_sram.gen_ihp_256x32.u_sram_256x32/A_BM[18]
+ bank_B_sram.gen_ihp_256x32.u_sram_256x32/A_BM[13] bank_B_sram.gen_ihp_256x32.u_sram_256x32_1124/L_LO
+ bank_B_sram.gen_ihp_256x32.u_sram_256x32_1119/L_LO output910/A output905/A input814/X
+ input807/X bank_B_sram.gen_ihp_256x32.u_sram_256x32_1158/L_LO bank_B_sram.gen_ihp_256x32.u_sram_256x32_1151/L_LO
+ bank_B_sram.gen_ihp_256x32.u_sram_256x32/A_BM[19] bank_B_sram.gen_ihp_256x32.u_sram_256x32/A_BM[12]
+ bank_B_sram.gen_ihp_256x32.u_sram_256x32_1125/L_LO bank_B_sram.gen_ihp_256x32.u_sram_256x32_1118/L_LO
+ output911/A output904/A input816/X input806/X bank_B_sram.gen_ihp_256x32.u_sram_256x32_1159/L_LO
+ bank_B_sram.gen_ihp_256x32.u_sram_256x32_1150/L_LO bank_B_sram.gen_ihp_256x32.u_sram_256x32/A_BM[20]
+ bank_B_sram.gen_ihp_256x32.u_sram_256x32/A_BM[11] bank_B_sram.gen_ihp_256x32.u_sram_256x32_1126/L_LO
+ bank_B_sram.gen_ihp_256x32.u_sram_256x32_1117/L_LO wire973/A output903/A input817/X
+ input805/X bank_B_sram.gen_ihp_256x32.u_sram_256x32_1160/L_LO bank_B_sram.gen_ihp_256x32.u_sram_256x32_1149/L_LO
+ bank_B_sram.gen_ihp_256x32.u_sram_256x32/A_BM[21] bank_B_sram.gen_ihp_256x32.u_sram_256x32/A_BM[10]
+ bank_B_sram.gen_ihp_256x32.u_sram_256x32_1127/L_LO bank_B_sram.gen_ihp_256x32.u_sram_256x32_1116/L_LO
+ wire972/A output902/A input818/X input835/X bank_B_sram.gen_ihp_256x32.u_sram_256x32_1161/L_LO
+ bank_B_sram.gen_ihp_256x32.u_sram_256x32_1148/L_LO bank_B_sram.gen_ihp_256x32.u_sram_256x32/A_BM[22]
+ bank_B_sram.gen_ihp_256x32.u_sram_256x32/A_BM[9] bank_B_sram.gen_ihp_256x32.u_sram_256x32_1128/L_LO
+ bank_B_sram.gen_ihp_256x32.u_sram_256x32_1115/L_LO wire971/A output932/A input819/X
+ input834/X bank_B_sram.gen_ihp_256x32.u_sram_256x32_1162/L_LO bank_B_sram.gen_ihp_256x32.u_sram_256x32_1147/L_LO
+ bank_B_sram.gen_ihp_256x32.u_sram_256x32/A_BM[23] bank_B_sram.gen_ihp_256x32.u_sram_256x32/A_BM[8]
+ bank_B_sram.gen_ihp_256x32.u_sram_256x32_1129/L_LO bank_B_sram.gen_ihp_256x32.u_sram_256x32_1114/L_LO
+ wire970/A output931/A input820/X input833/X bank_B_sram.gen_ihp_256x32.u_sram_256x32_1163/L_LO
+ bank_B_sram.gen_ihp_256x32.u_sram_256x32_1146/L_LO bank_B_sram.gen_ihp_256x32.u_sram_256x32/A_BM[24]
+ bank_B_sram.gen_ihp_256x32.u_sram_256x32/A_BM[7] bank_B_sram.gen_ihp_256x32.u_sram_256x32_1130/L_LO
+ bank_B_sram.gen_ihp_256x32.u_sram_256x32_1113/L_LO wire969/A _6227_/B input821/X
+ input832/X bank_B_sram.gen_ihp_256x32.u_sram_256x32_1164/L_LO bank_B_sram.gen_ihp_256x32.u_sram_256x32_1145/L_LO
+ bank_B_sram.gen_ihp_256x32.u_sram_256x32/A_BM[25] bank_B_sram.gen_ihp_256x32.u_sram_256x32/A_BM[6]
+ bank_B_sram.gen_ihp_256x32.u_sram_256x32_1131/L_LO bank_B_sram.gen_ihp_256x32.u_sram_256x32_1112/L_LO
+ wire968/A _6225_/B input822/X input831/X bank_B_sram.gen_ihp_256x32.u_sram_256x32_1165/L_LO
+ bank_B_sram.gen_ihp_256x32.u_sram_256x32_1144/L_LO bank_B_sram.gen_ihp_256x32.u_sram_256x32/A_BM[26]
+ bank_B_sram.gen_ihp_256x32.u_sram_256x32/A_BM[5] bank_B_sram.gen_ihp_256x32.u_sram_256x32_1132/L_LO
+ bank_B_sram.gen_ihp_256x32.u_sram_256x32_1111/L_LO wire967/A _6223_/B input823/X
+ input830/X bank_B_sram.gen_ihp_256x32.u_sram_256x32_1166/L_LO bank_B_sram.gen_ihp_256x32.u_sram_256x32_1143/L_LO
+ bank_B_sram.gen_ihp_256x32.u_sram_256x32/A_BM[27] bank_B_sram.gen_ihp_256x32.u_sram_256x32/A_BM[4]
+ bank_B_sram.gen_ihp_256x32.u_sram_256x32_1133/L_LO bank_B_sram.gen_ihp_256x32.u_sram_256x32_1110/L_LO
+ wire966/A _6221_/B input824/X input829/X bank_B_sram.gen_ihp_256x32.u_sram_256x32_1167/L_LO
+ bank_B_sram.gen_ihp_256x32.u_sram_256x32_1142/L_LO bank_B_sram.gen_ihp_256x32.u_sram_256x32/A_BM[28]
+ bank_B_sram.gen_ihp_256x32.u_sram_256x32/A_BM[3] bank_B_sram.gen_ihp_256x32.u_sram_256x32_1134/L_LO
+ bank_B_sram.gen_ihp_256x32.u_sram_256x32_1109/L_LO wire965/A _6219_/B input825/X
+ input826/X bank_B_sram.gen_ihp_256x32.u_sram_256x32_1168/L_LO bank_B_sram.gen_ihp_256x32.u_sram_256x32_1141/L_LO
+ bank_B_sram.gen_ihp_256x32.u_sram_256x32/A_BM[29] bank_B_sram.gen_ihp_256x32.u_sram_256x32/A_BM[2]
+ bank_B_sram.gen_ihp_256x32.u_sram_256x32_1135/L_LO bank_B_sram.gen_ihp_256x32.u_sram_256x32_1108/L_LO
+ wire964/A _6217_/B input827/X input815/X bank_B_sram.gen_ihp_256x32.u_sram_256x32_1169/L_LO
+ bank_B_sram.gen_ihp_256x32.u_sram_256x32_1140/L_LO bank_B_sram.gen_ihp_256x32.u_sram_256x32/A_BM[30]
+ bank_B_sram.gen_ihp_256x32.u_sram_256x32/A_BM[1] bank_B_sram.gen_ihp_256x32.u_sram_256x32_1136/L_LO
+ bank_B_sram.gen_ihp_256x32.u_sram_256x32_1107/L_LO wire963/A _6215_/B input828/X
+ input804/X bank_B_sram.gen_ihp_256x32.u_sram_256x32_1170/L_LO bank_B_sram.gen_ihp_256x32.u_sram_256x32_1139/L_LO
+ bank_B_sram.gen_ihp_256x32.u_sram_256x32/A_BM[31] bank_B_sram.gen_ihp_256x32.u_sram_256x32/A_BM[0]
+ bank_B_sram.gen_ihp_256x32.u_sram_256x32_1137/L_LO bank_B_sram.gen_ihp_256x32.u_sram_256x32_1106/L_LO
+ wire962/A _6213_/B _6188_/Y bank_B_sram.gen_ihp_256x32.u_sram_256x32_1098/L_LO _6191_/Y
+ bank_B_sram.gen_ihp_256x32.u_sram_256x32_1099/L_LO _6194_/Y bank_B_sram.gen_ihp_256x32.u_sram_256x32_1100/L_LO
+ _6197_/Y bank_B_sram.gen_ihp_256x32.u_sram_256x32_1101/L_LO _6200_/Y bank_B_sram.gen_ihp_256x32.u_sram_256x32_1102/L_LO
+ _6203_/Y bank_B_sram.gen_ihp_256x32.u_sram_256x32_1103/L_LO _6206_/Y bank_B_sram.gen_ihp_256x32.u_sram_256x32_1104/L_LO
+ _6209_/Y bank_B_sram.gen_ihp_256x32.u_sram_256x32_1105/L_LO clkbuf_1_0__f_clk_i/X
+ _6211_/Y _6211_/A bank_B_sram.gen_ihp_256x32.u_sram_256x32/A_MEN bank_B_sram.gen_ihp_256x32.u_sram_256x32/A_DLY
+ bank_B_sram.gen_ihp_256x32.u_sram_256x32_1171/L_LO bank_B_sram.gen_ihp_256x32.u_sram_256x32_1138/L_LO
+ bank_B_sram.gen_ihp_256x32.u_sram_256x32_1173/L_LO bank_B_sram.gen_ihp_256x32.u_sram_256x32_1174/L_LO
+ bank_B_sram.gen_ihp_256x32.u_sram_256x32_1172/L_LO RM_IHPSG13_1P_256x32_c2_bm_bist
X_6722_ _6722_/Y _6722_/A1 _6742_/B _6677_/B VDD VSS sg13cmos5l_a21oi_1
X_3934_ _3935_/A _3964_/A _4303_/B VDD VSS sg13cmos5l_nand2_1
X_6653_ _6661_/A _6734_/A _6733_/A _6734_/B VDD VSS sg13cmos5l_nand3_1
X_5604_ _5667_/B _5606_/B _5606_/A VDD VSS sg13cmos5l_nor2_1
X_6584_ _6585_/B _6582_/B _7692_/Q VDD VSS sg13cmos5l_nand2b_1
XFILLER_11_16 VDD VSS sg13cmos5l_decap_4
X_5535_ _5541_/B _5535_/A VDD VSS sg13cmos5l_inv_1
Xbank_A_sram.gen_ihp_256x32.u_sram_256x32_1024 bank_A_sram.gen_ihp_256x32.u_sram_256x32_1024/L_LO
+ VDD VSS sg13cmos5l_tielo
Xbank_A_sram.gen_ihp_256x32.u_sram_256x32_1035 bank_A_sram.gen_ihp_256x32.u_sram_256x32_1035/L_LO
+ VDD VSS sg13cmos5l_tielo
X_5466_ _5467_/B _5466_/A _5466_/B VDD VSS sg13cmos5l_xor2_1
Xbank_A_sram.gen_ihp_256x32.u_sram_256x32_1046 bank_A_sram.gen_ihp_256x32.u_sram_256x32_1046/L_LO
+ VDD VSS sg13cmos5l_tielo
Xbank_A_sram.gen_ihp_256x32.u_sram_256x32_1057 bank_A_sram.gen_ihp_256x32.u_sram_256x32_1057/L_LO
+ VDD VSS sg13cmos5l_tielo
Xbank_A_sram.gen_ihp_256x32.u_sram_256x32_1068 bank_A_sram.gen_ihp_256x32.u_sram_256x32_1068/L_LO
+ VDD VSS sg13cmos5l_tielo
X_7205_ _7205_/Y _7235_/B _7205_/B VDD VSS sg13cmos5l_nor2_1
X_4417_ _4418_/B _4417_/A _4417_/B VDD VSS sg13cmos5l_nand2_1
Xbank_A_sram.gen_ihp_256x32.u_sram_256x32_1079 bank_A_sram.gen_ihp_256x32.u_sram_256x32_1079/L_LO
+ VDD VSS sg13cmos5l_tielo
X_5397_ _5397_/Y _5397_/A _5397_/B VDD VSS sg13cmos5l_nor2_1
XFILLER_87_801 VDD VSS sg13cmos5l_decap_8
XFILLER_59_547 VDD VSS sg13cmos5l_fill_2
X_7136_ _7136_/X _7136_/A _7195_/B VDD VSS sg13cmos5l_and2_1
X_4348_ _4349_/B _4354_/B _4411_/A VDD VSS sg13cmos5l_nor2_1
X_7067_ _7067_/Y _7184_/B _7184_/A VDD VSS sg13cmos5l_nor2_1
X_4279_ _4280_/B _4171_/A _4592_/A2 _4127_/A _4531_/B2 VDD VSS sg13cmos5l_a22oi_1
XFILLER_87_878 VDD VSS sg13cmos5l_decap_8
XFILLER_86_344 VDD VSS sg13cmos5l_fill_2
X_6018_ _6046_/A _6018_/A _6018_/B _6018_/C VDD VSS sg13cmos5l_nand3_1
XFILLER_54_230 VDD VSS sg13cmos5l_decap_8
Xbank_B_sram.gen_ihp_256x32.u_sram_256x32_1099 bank_B_sram.gen_ihp_256x32.u_sram_256x32_1099/L_LO
+ VDD VSS sg13cmos5l_tielo
XFILLER_82_572 VDD VSS sg13cmos5l_fill_1
XFILLER_54_285 VDD VSS sg13cmos5l_fill_2
XFILLER_82_594 VDD VSS sg13cmos5l_decap_8
XFILLER_78_856 VDD VSS sg13cmos5l_decap_8
XFILLER_37_219 VDD VSS sg13cmos5l_decap_8
XFILLER_45_274 VDD VSS sg13cmos5l_decap_8
XFILLER_45_296 VDD VSS sg13cmos5l_decap_8
XFILLER_61_745 VDD VSS sg13cmos5l_fill_2
XFILLER_60_288 VDD VSS sg13cmos5l_decap_8
XFILLER_61_4 VDD VSS sg13cmos5l_fill_2
X_5320_ _5321_/B _5622_/B1 _5380_/A2 _5557_/B1 _6021_/B2 VDD VSS sg13cmos5l_a22oi_1
X_5251_ _5252_/B _5305_/A _5305_/B VDD VSS sg13cmos5l_xor2_1
XFILLER_69_801 VDD VSS sg13cmos5l_decap_8
XFILLER_68_300 VDD VSS sg13cmos5l_fill_1
X_5182_ _5182_/X _5182_/A _5182_/B VDD VSS sg13cmos5l_and2_1
XFILLER_68_333 VDD VSS sg13cmos5l_fill_2
XFILLER_69_878 VDD VSS sg13cmos5l_decap_8
X_4133_ _4134_/B _4165_/A _4165_/B VDD VSS sg13cmos5l_xor2_1
XFILLER_113_18 VDD VSS sg13cmos5l_fill_2
XFILLER_68_388 VDD VSS sg13cmos5l_decap_8
XFILLER_68_399 VDD VSS sg13cmos5l_decap_8
X_4064_ _4064_/Y _4064_/A _4095_/A VDD VSS sg13cmos5l_xnor2_1
XFILLER_37_731 VDD VSS sg13cmos5l_decap_8
XFILLER_37_742 VDD VSS sg13cmos5l_decap_4
XFILLER_40_907 VDD VSS sg13cmos5l_decap_8
XFILLER_51_233 VDD VSS sg13cmos5l_decap_8
XFILLER_51_266 VDD VSS sg13cmos5l_decap_8
X_6705_ _6705_/Y _6703_/Y _6598_/C _6704_/Y VDD VSS sg13cmos5l_a21oi_1
X_4966_ _5035_/B _4978_/B _4978_/A VDD VSS sg13cmos5l_xor2_1
X_7685_ _7685_/Q _7704_/CLK _7685_/D place754/A VDD VSS sg13cmos5l_dfrbpq_1
X_4897_ _4959_/B _4897_/A _4897_/B VDD VSS sg13cmos5l_xor2_1
X_6636_ _6637_/B _6634_/B _7698_/Q VDD VSS sg13cmos5l_nand2b_1
X_6567_ _6579_/A _6567_/A _6567_/B _6567_/C VDD VSS sg13cmos5l_and3_1
XFILLER_118_8 VDD VSS sg13cmos5l_decap_8
X_5518_ _5518_/Y _5517_/A _5460_/C _5519_/A VDD VSS sg13cmos5l_o21ai_1
X_6498_ _6978_/B _6533_/C VDD VSS sg13cmos5l_inv_1
X_5449_ _5450_/B _5508_/B1 _5871_/A2 _5792_/B1 _5871_/B2 VDD VSS sg13cmos5l_a22oi_1
XFILLER_59_311 VDD VSS sg13cmos5l_decap_8
XFILLER_59_322 VDD VSS sg13cmos5l_fill_1
XFILLER_87_620 VDD VSS sg13cmos5l_fill_2
Xfanout154 _5302_/A _5242_/A VDD VSS sg13cmos5l_buf_1
X_7119_ _7119_/Y _7110_/Y _6557_/A _7118_/Y VDD VSS sg13cmos5l_a21oi_1
XFILLER_47_23 VDD VSS sg13cmos5l_fill_2
Xfanout187 _5060_/A _4931_/A VDD VSS sg13cmos5l_buf_1
XFILLER_87_675 VDD VSS sg13cmos5l_decap_8
XFILLER_74_369 VDD VSS sg13cmos5l_decap_8
XFILLER_55_594 VDD VSS sg13cmos5l_fill_1
XFILLER_82_380 VDD VSS sg13cmos5l_fill_1
XFILLER_42_222 VDD VSS sg13cmos5l_decap_4
XFILLER_70_531 VDD VSS sg13cmos5l_fill_1
XFILLER_42_277 VDD VSS sg13cmos5l_fill_2
XFILLER_70_597 VDD VSS sg13cmos5l_decap_4
XFILLER_38_506 VDD VSS sg13cmos5l_decap_8
XFILLER_78_697 VDD VSS sg13cmos5l_decap_8
XFILLER_66_859 VDD VSS sg13cmos5l_decap_8
XFILLER_74_892 VDD VSS sg13cmos5l_decap_8
X_4820_ _4821_/B _4588_/A _5009_/A2 _4820_/B1 _5140_/B2 VDD VSS sg13cmos5l_a22oi_1
X_7470_ _7477_/B _7472_/A1 _7268_/Y _7472_/B1 VDD VSS sg13cmos5l_o21ai_1
X_4682_ _4683_/B _4682_/A _4734_/A VDD VSS sg13cmos5l_xnor2_1
X_6421_ _6421_/Y _6421_/A _6420_/A VDD VSS sg13cmos5l_nor2b_1
X_6352_ _6812_/B _6352_/A _6352_/B VDD VSS sg13cmos5l_nand2_2
X_6283_ _6284_/A _6293_/B _6293_/A VDD VSS sg13cmos5l_xnor2_1
X_5303_ _5355_/A _5303_/A _5303_/B VDD VSS sg13cmos5l_and2_1
X_5234_ _5234_/X _5234_/A _5234_/B VDD VSS sg13cmos5l_and2_1
XFILLER_88_428 VDD VSS sg13cmos5l_decap_8
X_5165_ _5229_/A _5172_/A _5165_/B VDD VSS sg13cmos5l_xnor2_1
XFILLER_68_163 VDD VSS sg13cmos5l_decap_8
X_4116_ _4153_/B _4422_/A _5978_/B _4158_/B VDD VSS sg13cmos5l_nor3_1
XFILLER_68_174 VDD VSS sg13cmos5l_fill_1
X_5096_ _5096_/X _5096_/A _5096_/B VDD VSS sg13cmos5l_and2_1
XFILLER_44_509 VDD VSS sg13cmos5l_fill_1
XFILLER_84_667 VDD VSS sg13cmos5l_decap_8
XFILLER_83_166 VDD VSS sg13cmos5l_decap_8
XFILLER_65_892 VDD VSS sg13cmos5l_decap_8
X_5998_ _5998_/Y _5998_/A VDD VSS sg13cmos5l_inv_1
X_4949_ _5007_/A _4947_/B _4888_/A _4948_/Y VDD VSS sg13cmos5l_a21o_1
X_7668_ _7668_/Q clkload4/A _7668_/D place746/X VDD VSS sg13cmos5l_dfrbpq_1
X_6619_ _6620_/B _6617_/B _7696_/Q VDD VSS sg13cmos5l_nand2b_1
X_7599_ _7627_/B _7599_/A _7599_/B VDD VSS sg13cmos5l_xnor2_1
XFILLER_79_439 VDD VSS sg13cmos5l_fill_2
XFILLER_59_130 VDD VSS sg13cmos5l_fill_1
XFILLER_58_66 VDD VSS sg13cmos5l_fill_2
XFILLER_59_152 VDD VSS sg13cmos5l_fill_2
Xinput756 input756/X bank_A_addr[1] VDD VSS sg13cmos5l_buf_1
Xwire1000 _4825_/A wire1000/A VDD VSS sg13cmos5l_buf_2
Xwire1011 _4389_/A _4697_/B1 VDD VSS sg13cmos5l_buf_2
XFILLER_87_461 VDD VSS sg13cmos5l_fill_2
XFILLER_74_122 VDD VSS sg13cmos5l_fill_2
Xinput767 input767/X bank_A_wdata[13] VDD VSS sg13cmos5l_buf_1
Xinput778 input778/X bank_A_wdata[23] VDD VSS sg13cmos5l_buf_1
Xinput789 input789/X bank_A_wdata[4] VDD VSS sg13cmos5l_buf_1
XFILLER_74_32 VDD VSS sg13cmos5l_decap_8
XFILLER_74_199 VDD VSS sg13cmos5l_fill_2
XFILLER_74_76 VDD VSS sg13cmos5l_decap_8
XFILLER_71_851 VDD VSS sg13cmos5l_decap_8
Xrebuffer1409 rebuffer1409/X rebuffer1410/X VDD VSS sg13cmos5l_buf_1
XFILLER_66_601 VDD VSS sg13cmos5l_fill_1
XFILLER_66_612 VDD VSS sg13cmos5l_decap_4
XFILLER_78_461 VDD VSS sg13cmos5l_decap_8
XFILLER_39_848 VDD VSS sg13cmos5l_decap_8
XFILLER_66_645 VDD VSS sg13cmos5l_decap_8
XFILLER_65_133 VDD VSS sg13cmos5l_decap_8
XFILLER_65_144 VDD VSS sg13cmos5l_fill_2
XFILLER_66_667 VDD VSS sg13cmos5l_decap_8
X_6970_ _6970_/Y _6970_/A _6974_/B VDD VSS sg13cmos5l_nand2_1
X_5921_ _5925_/A _5961_/A _5921_/B VDD VSS sg13cmos5l_xnor2_1
XFILLER_81_637 VDD VSS sg13cmos5l_decap_8
XFILLER_110_19 VDD VSS sg13cmos5l_fill_2
XFILLER_61_361 VDD VSS sg13cmos5l_fill_1
XFILLER_62_873 VDD VSS sg13cmos5l_decap_8
X_5852_ _5852_/Y _5852_/A _5799_/A VDD VSS sg13cmos5l_nor2b_1
X_5783_ _5845_/A _5927_/A _5729_/B _5782_/Y VDD VSS sg13cmos5l_o21ai_1
X_4803_ _4803_/X _4803_/A _4803_/B VDD VSS sg13cmos5l_and2_1
X_7522_ _7523_/A _7522_/A1 _7524_/A _7342_/B VDD VSS sg13cmos5l_a21oi_1
X_4734_ _4734_/Y _4734_/A _4682_/A VDD VSS sg13cmos5l_nor2b_1
X_7453_ _7458_/A _7453_/A _7453_/B _7589_/B VDD VSS sg13cmos5l_nand3_1
X_4665_ _4671_/B _4665_/A _4665_/B VDD VSS sg13cmos5l_xnor2_1
X_7384_ _7509_/B _7387_/B _7570_/B VDD VSS sg13cmos5l_nand2_1
X_6404_ _6406_/A _6827_/B _6827_/A VDD VSS sg13cmos5l_nand2_2
X_4596_ _4597_/B _4627_/A _4596_/B VDD VSS sg13cmos5l_xnor2_1
X_6335_ _6342_/B _6335_/A _6335_/B VDD VSS sg13cmos5l_nor2_2
Xrebuffer1921 rebuffer1921/X rebuffer1922/X VDD VSS sg13cmos5l_buf_1
Xrebuffer1910 rebuffer1910/X rebuffer1911/X VDD VSS sg13cmos5l_buf_1
XFILLER_88_214 VDD VSS sg13cmos5l_fill_1
Xrebuffer1954 rebuffer1954/X rebuffer1955/X VDD VSS sg13cmos5l_buf_1
Xrebuffer1943 rebuffer1943/X rebuffer1944/X VDD VSS sg13cmos5l_buf_1
Xrebuffer1932 rebuffer1932/X rebuffer1933/X VDD VSS sg13cmos5l_buf_1
X_6266_ _6267_/B _6266_/A VDD VSS sg13cmos5l_inv_1
XFILLER_88_247 VDD VSS sg13cmos5l_fill_2
XFILLER_57_612 VDD VSS sg13cmos5l_fill_2
Xrebuffer1998 _4120_/B _4091_/A VDD VSS sg13cmos5l_buf_1
Xrebuffer1987 rebuffer1987/X rebuffer1988/X VDD VSS sg13cmos5l_buf_1
Xrebuffer1976 rebuffer1976/X rebuffer1977/X VDD VSS sg13cmos5l_buf_1
Xrebuffer1965 rebuffer1965/X rebuffer1966/X VDD VSS sg13cmos5l_buf_1
X_6197_ _6197_/Y _6209_/A1 _6195_/Y _6196_/Y VDD VSS sg13cmos5l_a21oi_1
X_5217_ _5219_/A _5156_/B _5217_/B VDD VSS sg13cmos5l_nand2b_1
XFILLER_57_634 VDD VSS sg13cmos5l_decap_8
X_5148_ _5197_/A _5206_/B _5076_/A _5147_/Y VDD VSS sg13cmos5l_a21o_1
X_5079_ _5138_/A _5206_/B _5013_/A _5078_/Y VDD VSS sg13cmos5l_a21o_1
XFILLER_38_870 VDD VSS sg13cmos5l_decap_8
XFILLER_72_659 VDD VSS sg13cmos5l_decap_8
XFILLER_53_895 VDD VSS sg13cmos5l_decap_8
XFILLER_80_670 VDD VSS sg13cmos5l_decap_8
XFILLER_40_567 VDD VSS sg13cmos5l_fill_1
XFILLER_60_56 VDD VSS sg13cmos5l_fill_2
XFILLER_5_18 VDD VSS sg13cmos5l_fill_2
XFILLER_76_910 VDD VSS sg13cmos5l_decap_8
XFILLER_47_111 VDD VSS sg13cmos5l_fill_1
XFILLER_47_122 VDD VSS sg13cmos5l_fill_1
XFILLER_85_75 VDD VSS sg13cmos5l_fill_2
Xplace604 _6021_/A2 _5981_/A2 VDD VSS sg13cmos5l_buf_1
Xplace615 _5966_/A _5927_/A VDD VSS sg13cmos5l_buf_1
Xplace626 _4767_/B _4525_/B VDD VSS sg13cmos5l_buf_1
Xplace637 _4859_/B1 wire980/X VDD VSS sg13cmos5l_buf_1
XFILLER_44_862 VDD VSS sg13cmos5l_decap_8
XFILLER_50_309 VDD VSS sg13cmos5l_decap_4
Xplace648 _5801_/B1 _5145_/A VDD VSS sg13cmos5l_buf_1
Xplace659 _5066_/B1 _4820_/B1 VDD VSS sg13cmos5l_buf_1
XFILLER_70_180 VDD VSS sg13cmos5l_decap_4
X_4450_ _4451_/B _4326_/A _4592_/A2 _4275_/A _4531_/B2 VDD VSS sg13cmos5l_a22oi_1
X_4381_ _4457_/B _4381_/A _4381_/B VDD VSS sg13cmos5l_xor2_1
X_6120_ _6145_/B _6120_/A _6123_/B VDD VSS sg13cmos5l_nand2_1
X_6051_ _6094_/B _6051_/A _6032_/A VDD VSS sg13cmos5l_nor2b_1
XFILLER_79_770 VDD VSS sg13cmos5l_decap_8
XFILLER_39_612 VDD VSS sg13cmos5l_fill_2
X_5002_ _5054_/A _5442_/A _5002_/B VDD VSS sg13cmos5l_xnor2_1
XFILLER_85_228 VDD VSS sg13cmos5l_fill_2
XFILLER_82_902 VDD VSS sg13cmos5l_decap_8
XFILLER_39_689 VDD VSS sg13cmos5l_fill_2
XFILLER_54_637 VDD VSS sg13cmos5l_fill_1
XFILLER_66_497 VDD VSS sg13cmos5l_decap_8
XFILLER_121_18 VDD VSS sg13cmos5l_fill_2
X_6953_ _6953_/X _6953_/A _7144_/B VDD VSS sg13cmos5l_and2_1
XFILLER_41_309 VDD VSS sg13cmos5l_fill_2
XFILLER_53_158 VDD VSS sg13cmos5l_decap_8
XFILLER_53_169 VDD VSS sg13cmos5l_fill_2
X_6884_ _6884_/Y _6883_/Y _6927_/B VDD VSS sg13cmos5l_nand2b_1
X_5904_ _5905_/B _5904_/A _5945_/A VDD VSS sg13cmos5l_nand2_1
X_5835_ _5837_/A _5835_/A _5835_/B VDD VSS sg13cmos5l_nor2_1
XFILLER_50_876 VDD VSS sg13cmos5l_decap_8
X_5766_ _5767_/B _5797_/A _5797_/B VDD VSS sg13cmos5l_xor2_1
X_7505_ _7620_/A _7504_/Y _7510_/A VDD VSS sg13cmos5l_nand2b_1
X_5697_ _5704_/A _5982_/A _5697_/B VDD VSS sg13cmos5l_xnor2_1
X_4717_ _4720_/A _4732_/A _4717_/B VDD VSS sg13cmos5l_xnor2_1
X_7436_ _7587_/A _7460_/A _7436_/B VDD VSS sg13cmos5l_xnor2_1
X_4648_ _4648_/Y _4648_/A _4648_/B VDD VSS sg13cmos5l_nor2_1
X_7367_ _7513_/A _7359_/A _7380_/B VDD VSS sg13cmos5l_nand2b_1
X_4579_ _4580_/B _4623_/A _4623_/B VDD VSS sg13cmos5l_xor2_1
X_7298_ _7298_/Y _7298_/A1 _7136_/A _7297_/Y VDD VSS sg13cmos5l_o21ai_1
X_6318_ _6787_/A _6318_/A _6317_/Y VDD VSS sg13cmos5l_nor2b_2
X_6249_ _6250_/A _6249_/A _6261_/B VDD VSS sg13cmos5l_nand2_2
XFILLER_85_751 VDD VSS sg13cmos5l_decap_8
XFILLER_45_626 VDD VSS sg13cmos5l_decap_8
XFILLER_55_23 VDD VSS sg13cmos5l_decap_4
XFILLER_41_810 VDD VSS sg13cmos5l_decap_8
XFILLER_60_607 VDD VSS sg13cmos5l_fill_1
XFILLER_40_320 VDD VSS sg13cmos5l_fill_1
XFILLER_71_33 VDD VSS sg13cmos5l_fill_1
XFILLER_71_44 VDD VSS sg13cmos5l_fill_1
XFILLER_71_55 VDD VSS sg13cmos5l_decap_8
XFILLER_41_887 VDD VSS sg13cmos5l_decap_8
XFILLER_71_88 VDD VSS sg13cmos5l_decap_8
XFILLER_68_729 VDD VSS sg13cmos5l_decap_8
XFILLER_48_431 VDD VSS sg13cmos5l_decap_4
XFILLER_76_762 VDD VSS sg13cmos5l_fill_1
XFILLER_76_784 VDD VSS sg13cmos5l_decap_8
XFILLER_63_423 VDD VSS sg13cmos5l_fill_2
XFILLER_63_456 VDD VSS sg13cmos5l_fill_1
XFILLER_63_467 VDD VSS sg13cmos5l_fill_1
X_5620_ _5658_/A _5564_/B _5564_/A _5619_/Y VDD VSS sg13cmos5l_a21oi_1
X_5551_ _5553_/A _5552_/A _5552_/B _5552_/C VDD VSS sg13cmos5l_a21oi_1
X_4502_ _4502_/Y _4503_/B _4503_/A VDD VSS sg13cmos5l_nor2_1
Xbank_A_sram.gen_ihp_256x32.u_sram_256x32_1206 bank_A_sram.gen_ihp_256x32.u_sram_256x32/A_BM[31]
+ VDD VSS sg13cmos5l_tiehi
X_7221_ _7222_/B _7296_/A _7221_/B VDD VSS sg13cmos5l_nor2_1
X_5482_ _5489_/C _5483_/B _5482_/B VDD VSS sg13cmos5l_nand2b_1
Xoutput868 act_out[7] _6228_/Y VDD VSS sg13cmos5l_buf_1
Xoutput879 bank_A_rdata[19] wire1003/A VDD VSS sg13cmos5l_buf_1
X_7152_ _7152_/Y _7178_/S _6994_/A _7126_/B VDD VSS sg13cmos5l_o21ai_1
X_4364_ _4364_/Y _6111_/B _6110_/B VDD VSS sg13cmos5l_nand2_1
X_7083_ _7083_/Y _6975_/Y _7078_/B _6807_/A VDD VSS sg13cmos5l_a21oi_1
X_6103_ _6103_/X _6103_/A _6103_/B VDD VSS sg13cmos5l_and2_1
X_4295_ _4343_/A _4295_/A _4295_/B VDD VSS sg13cmos5l_nand2_1
XFILLER_58_217 VDD VSS sg13cmos5l_decap_8
X_6034_ _6035_/B _6068_/A _6068_/B VDD VSS sg13cmos5l_xor2_1
XFILLER_39_453 VDD VSS sg13cmos5l_decap_8
XFILLER_55_902 VDD VSS sg13cmos5l_decap_8
Xbank_B_sram.gen_ihp_256x32.u_sram_256x32_1215 bank_B_sram.gen_ihp_256x32.u_sram_256x32/A_BM[6]
+ VDD VSS sg13cmos5l_tiehi
Xbank_B_sram.gen_ihp_256x32.u_sram_256x32_1226 bank_B_sram.gen_ihp_256x32.u_sram_256x32/A_BM[17]
+ VDD VSS sg13cmos5l_tiehi
Xbank_B_sram.gen_ihp_256x32.u_sram_256x32_1237 bank_B_sram.gen_ihp_256x32.u_sram_256x32/A_BM[28]
+ VDD VSS sg13cmos5l_tiehi
XFILLER_66_250 VDD VSS sg13cmos5l_decap_8
XFILLER_66_261 VDD VSS sg13cmos5l_fill_1
XFILLER_54_423 VDD VSS sg13cmos5l_fill_1
XFILLER_42_618 VDD VSS sg13cmos5l_decap_8
X_6936_ _7134_/A _7072_/A _7061_/B _6935_/X VDD VSS sg13cmos5l_a21oi_1
XFILLER_82_776 VDD VSS sg13cmos5l_decap_8
XFILLER_81_286 VDD VSS sg13cmos5l_fill_1
XFILLER_81_275 VDD VSS sg13cmos5l_decap_8
X_6867_ _7029_/A _6867_/A VDD VSS sg13cmos5l_inv_2
XFILLER_50_695 VDD VSS sg13cmos5l_decap_8
X_6798_ _6798_/Y _6798_/A _6798_/B VDD VSS sg13cmos5l_xnor2_1
X_5818_ _5855_/A _5768_/B _5768_/A _5817_/X VDD VSS sg13cmos5l_a21o_1
X_5749_ _5749_/X _5749_/A _5749_/B VDD VSS sg13cmos5l_and2_1
X_7419_ _7431_/A _7318_/Y _7397_/A _7399_/A VDD VSS sg13cmos5l_a21o_1
XFILLER_2_19 VDD VSS sg13cmos5l_fill_2
XFILLER_66_99 VDD VSS sg13cmos5l_fill_2
XFILLER_73_732 VDD VSS sg13cmos5l_decap_4
XFILLER_73_765 VDD VSS sg13cmos5l_decap_4
XFILLER_82_54 VDD VSS sg13cmos5l_fill_1
XFILLER_40_161 VDD VSS sg13cmos5l_decap_8
XFILLER_41_684 VDD VSS sg13cmos5l_fill_2
XFILLER_40_172 VDD VSS sg13cmos5l_fill_2
XFILLER_68_515 VDD VSS sg13cmos5l_decap_8
XFILLER_68_537 VDD VSS sg13cmos5l_decap_8
X_4080_ _4093_/B _4080_/A1 _4063_/A _4079_/Y VDD VSS sg13cmos5l_a21oi_2
XFILLER_49_762 VDD VSS sg13cmos5l_decap_4
XFILLER_83_518 VDD VSS sg13cmos5l_fill_2
XFILLER_64_732 VDD VSS sg13cmos5l_decap_8
XFILLER_63_264 VDD VSS sg13cmos5l_fill_2
XFILLER_64_787 VDD VSS sg13cmos5l_decap_4
X_4982_ _4982_/Y _4982_/A _4926_/A VDD VSS sg13cmos5l_nor2b_1
X_6721_ _6721_/Y _6721_/A _6721_/B VDD VSS sg13cmos5l_xnor2_1
X_6652_ _6733_/A _6652_/A VDD VSS sg13cmos5l_inv_1
X_5603_ _5606_/A _5603_/A VDD VSS sg13cmos5l_inv_1
XFILLER_82_0 VDD VSS sg13cmos5l_fill_1
X_6583_ _6585_/A _6583_/A _6771_/A VDD VSS sg13cmos5l_nand2_2
X_5534_ _5535_/A _5601_/A _5534_/B VDD VSS sg13cmos5l_xnor2_1
Xbank_A_sram.gen_ihp_256x32.u_sram_256x32_1025 bank_A_sram.gen_ihp_256x32.u_sram_256x32_1025/L_LO
+ VDD VSS sg13cmos5l_tielo
X_5465_ _5466_/B _5512_/A _5512_/B VDD VSS sg13cmos5l_xor2_1
Xbank_A_sram.gen_ihp_256x32.u_sram_256x32_1036 bank_A_sram.gen_ihp_256x32.u_sram_256x32_1036/L_LO
+ VDD VSS sg13cmos5l_tielo
Xbank_A_sram.gen_ihp_256x32.u_sram_256x32_1047 bank_A_sram.gen_ihp_256x32.u_sram_256x32_1047/L_LO
+ VDD VSS sg13cmos5l_tielo
Xbank_A_sram.gen_ihp_256x32.u_sram_256x32_1058 bank_A_sram.gen_ihp_256x32.u_sram_256x32_1058/L_LO
+ VDD VSS sg13cmos5l_tielo
Xbank_A_sram.gen_ihp_256x32.u_sram_256x32_1069 bank_A_sram.gen_ihp_256x32.u_sram_256x32_1069/L_LO
+ VDD VSS sg13cmos5l_tielo
X_4416_ _4418_/A _4416_/A _4416_/B VDD VSS sg13cmos5l_nand2_1
X_7135_ _7136_/A _7134_/B _6944_/Y _7134_/Y VDD VSS sg13cmos5l_o21ai_1
X_5396_ _5397_/B _5460_/A _5460_/B _5396_/C VDD VSS sg13cmos5l_nor3_1
XFILLER_59_537 VDD VSS sg13cmos5l_fill_1
X_4347_ _4411_/A _4347_/A _4249_/A VDD VSS sg13cmos5l_nor2b_1
X_7066_ _7184_/A _6943_/B _7082_/B _7065_/X VDD VSS sg13cmos5l_a21oi_1
X_4278_ _4319_/A _4447_/B _4218_/A _4277_/Y VDD VSS sg13cmos5l_a21o_1
XFILLER_87_857 VDD VSS sg13cmos5l_decap_8
XFILLER_46_209 VDD VSS sg13cmos5l_decap_8
XFILLER_67_570 VDD VSS sg13cmos5l_fill_2
X_6017_ _7699_/D _6017_/A _6017_/B VDD VSS sg13cmos5l_xnor2_1
XFILLER_54_264 VDD VSS sg13cmos5l_decap_8
X_6919_ _7054_/A _6918_/B _6732_/Y _6918_/Y VDD VSS sg13cmos5l_o21ai_1
XFILLER_78_835 VDD VSS sg13cmos5l_decap_8
XFILLER_77_54 VDD VSS sg13cmos5l_decap_8
XFILLER_77_312 VDD VSS sg13cmos5l_decap_4
XFILLER_77_76 VDD VSS sg13cmos5l_decap_4
XFILLER_77_356 VDD VSS sg13cmos5l_decap_8
XFILLER_58_570 VDD VSS sg13cmos5l_fill_1
XFILLER_65_518 VDD VSS sg13cmos5l_fill_2
XFILLER_77_389 VDD VSS sg13cmos5l_fill_1
XFILLER_77_367 VDD VSS sg13cmos5l_fill_1
XFILLER_46_732 VDD VSS sg13cmos5l_fill_1
XFILLER_61_702 VDD VSS sg13cmos5l_fill_1
XFILLER_73_540 VDD VSS sg13cmos5l_decap_8
XFILLER_60_223 VDD VSS sg13cmos5l_decap_4
XFILLER_41_481 VDD VSS sg13cmos5l_decap_8
X_5250_ _5305_/B _5196_/B _5196_/A _5249_/X VDD VSS sg13cmos5l_a21oi_1
X_4201_ _4203_/A _6053_/B _6052_/A VDD VSS sg13cmos5l_nor2b_1
XFILLER_87_109 VDD VSS sg13cmos5l_decap_8
X_5181_ _5184_/A _5243_/S _5181_/B VDD VSS sg13cmos5l_xnor2_1
XFILLER_68_345 VDD VSS sg13cmos5l_fill_2
XFILLER_69_857 VDD VSS sg13cmos5l_decap_8
X_4132_ _4165_/B _4532_/A _4132_/B VDD VSS sg13cmos5l_xnor2_1
X_4063_ _4064_/A _4063_/A _4063_/B VDD VSS sg13cmos5l_xor2_1
XFILLER_84_849 VDD VSS sg13cmos5l_decap_8
XFILLER_83_348 VDD VSS sg13cmos5l_fill_1
XFILLER_83_337 VDD VSS sg13cmos5l_decap_8
XFILLER_37_765 VDD VSS sg13cmos5l_decap_4
XFILLER_64_540 VDD VSS sg13cmos5l_fill_1
XFILLER_52_735 VDD VSS sg13cmos5l_decap_8
X_4965_ _4978_/A _4979_/B _4979_/A VDD VSS sg13cmos5l_xor2_1
XFILLER_51_278 VDD VSS sg13cmos5l_decap_8
XFILLER_51_289 VDD VSS sg13cmos5l_fill_2
X_6704_ _6704_/Y _7706_/Q VDD VSS sg13cmos5l_inv_1
XFILLER_60_790 VDD VSS sg13cmos5l_decap_4
X_7684_ _7684_/Q clkload5/A _7684_/D place754/A VDD VSS sg13cmos5l_dfrbpq_1
X_4896_ _4897_/B _4928_/A _4896_/B VDD VSS sg13cmos5l_xnor2_1
X_6635_ _6637_/A _6754_/B _6754_/A VDD VSS sg13cmos5l_nand2_2
X_6566_ _6566_/Y _6567_/C _6567_/A VDD VSS sg13cmos5l_nor2_1
Xclkbuf_1_1__f_clk_i clkbuf_1_1__f_clk_i/X clkbuf_0_clk_i/X VDD VSS sg13cmos5l_buf_16
X_5517_ _5519_/A _5517_/A _5705_/A VDD VSS sg13cmos5l_nand2_1
X_6497_ _6505_/A _6497_/A _6836_/A _6837_/B VDD VSS sg13cmos5l_nand3_1
X_5379_ _5405_/A _5343_/B _5343_/A _5378_/Y VDD VSS sg13cmos5l_a21oi_1
XFILLER_59_334 VDD VSS sg13cmos5l_fill_2
X_7118_ _7118_/Y _7290_/A _7118_/B VDD VSS sg13cmos5l_nand2b_1
XFILLER_87_654 VDD VSS sg13cmos5l_decap_8
XFILLER_59_356 VDD VSS sg13cmos5l_decap_8
X_7049_ _7126_/B _7484_/B _7178_/S VDD VSS sg13cmos5l_nand2_2
XFILLER_75_849 VDD VSS sg13cmos5l_decap_8
XFILLER_74_359 VDD VSS sg13cmos5l_fill_1
XFILLER_42_201 VDD VSS sg13cmos5l_fill_1
XFILLER_55_573 VDD VSS sg13cmos5l_decap_4
XFILLER_70_521 VDD VSS sg13cmos5l_fill_2
XFILLER_63_34 VDD VSS sg13cmos5l_fill_1
XFILLER_42_256 VDD VSS sg13cmos5l_fill_2
XFILLER_88_97 VDD VSS sg13cmos5l_fill_1
XFILLER_77_131 VDD VSS sg13cmos5l_fill_1
XFILLER_77_120 VDD VSS sg13cmos5l_decap_8
XFILLER_38_529 VDD VSS sg13cmos5l_decap_8
XFILLER_66_838 VDD VSS sg13cmos5l_decap_8
XFILLER_78_676 VDD VSS sg13cmos5l_decap_8
XFILLER_81_819 VDD VSS sg13cmos5l_decap_8
XFILLER_46_584 VDD VSS sg13cmos5l_fill_1
XFILLER_46_595 VDD VSS sg13cmos5l_decap_4
XFILLER_74_871 VDD VSS sg13cmos5l_decap_8
XFILLER_61_565 VDD VSS sg13cmos5l_decap_8
XFILLER_61_598 VDD VSS sg13cmos5l_decap_4
X_4681_ _4734_/A _4637_/B _4637_/A _4680_/X VDD VSS sg13cmos5l_a21oi_1
X_6420_ _6431_/A _6420_/A _6420_/B VDD VSS sg13cmos5l_nor2_2
Xclkbuf_4_2_0_clk_i_regs _7679_/CLK clkbuf_0_clk_i_regs/X VDD VSS sg13cmos5l_buf_8
X_6351_ _6352_/B _6349_/A _7667_/Q VDD VSS sg13cmos5l_nand2b_1
XFILLER_108_19 VDD VSS sg13cmos5l_fill_2
X_5302_ _5480_/A _5302_/A VDD VSS sg13cmos5l_buf_1
X_6282_ _6293_/A _6323_/A _6586_/B VDD VSS sg13cmos5l_nor2_2
XFILLER_88_407 VDD VSS sg13cmos5l_decap_4
XFILLER_69_621 VDD VSS sg13cmos5l_fill_2
X_5233_ _5236_/A _5233_/A _5233_/B VDD VSS sg13cmos5l_nand2_1
X_5164_ _5165_/B _5173_/B _5173_/A VDD VSS sg13cmos5l_xor2_1
XFILLER_69_665 VDD VSS sg13cmos5l_fill_1
X_4115_ _4158_/B _5977_/A VDD VSS sg13cmos5l_inv_1
XFILLER_68_197 VDD VSS sg13cmos5l_decap_8
X_5095_ _5110_/B _5095_/A _5095_/B VDD VSS sg13cmos5l_xor2_1
XFILLER_84_646 VDD VSS sg13cmos5l_decap_8
XFILLER_65_871 VDD VSS sg13cmos5l_decap_8
X_5997_ _6004_/B _5997_/A VDD VSS sg13cmos5l_inv_1
XFILLER_80_885 VDD VSS sg13cmos5l_decap_8
X_4948_ _4948_/Y _4948_/A _4948_/B VDD VSS sg13cmos5l_nor2_1
X_7667_ _7667_/Q clkload3/A _7667_/D place746/X VDD VSS sg13cmos5l_dfrbpq_1
X_4879_ _4924_/B _5194_/A _4879_/B VDD VSS sg13cmos5l_xnor2_1
X_6618_ _6620_/A _6756_/B _6756_/A VDD VSS sg13cmos5l_nand2_2
X_7598_ _7599_/B _7598_/A _7598_/B VDD VSS sg13cmos5l_nand2_2
X_6549_ _6560_/B _6549_/A _6549_/B VDD VSS sg13cmos5l_nand2_2
XFILLER_79_429 VDD VSS sg13cmos5l_fill_2
XFILLER_58_34 VDD VSS sg13cmos5l_fill_1
XFILLER_48_805 VDD VSS sg13cmos5l_fill_1
Xwire1001 _4162_/A1 _4562_/B1 VDD VSS sg13cmos5l_buf_2
Xwire1012 _4697_/B1 wire1012/A VDD VSS sg13cmos5l_buf_2
XFILLER_87_440 VDD VSS sg13cmos5l_decap_8
XFILLER_47_337 VDD VSS sg13cmos5l_decap_8
XFILLER_48_849 VDD VSS sg13cmos5l_decap_8
XFILLER_59_175 VDD VSS sg13cmos5l_fill_1
Xinput757 input757/X bank_A_addr[2] VDD VSS sg13cmos5l_buf_1
Xinput768 input768/X bank_A_wdata[14] VDD VSS sg13cmos5l_buf_1
Xinput779 input779/X bank_A_wdata[24] VDD VSS sg13cmos5l_buf_1
XFILLER_87_495 VDD VSS sg13cmos5l_decap_8
XFILLER_87_484 VDD VSS sg13cmos5l_fill_1
XFILLER_63_819 VDD VSS sg13cmos5l_decap_8
XFILLER_56_882 VDD VSS sg13cmos5l_decap_8
XFILLER_62_329 VDD VSS sg13cmos5l_fill_1
XFILLER_71_830 VDD VSS sg13cmos5l_decap_8
XFILLER_70_351 VDD VSS sg13cmos5l_decap_4
XFILLER_38_304 VDD VSS sg13cmos5l_fill_2
XFILLER_39_827 VDD VSS sg13cmos5l_decap_8
XFILLER_17_4 VDD VSS sg13cmos5l_decap_8
XFILLER_38_337 VDD VSS sg13cmos5l_decap_4
XFILLER_47_893 VDD VSS sg13cmos5l_decap_8
X_5920_ _5921_/B _5962_/A _5962_/B VDD VSS sg13cmos5l_xor2_1
XFILLER_81_616 VDD VSS sg13cmos5l_decap_8
XFILLER_62_852 VDD VSS sg13cmos5l_decap_8
X_5851_ _5882_/A _5851_/A _5851_/B VDD VSS sg13cmos5l_nand2_1
X_5782_ _5782_/Y _5782_/A _5782_/B VDD VSS sg13cmos5l_nand2_1
X_4802_ _4805_/A _4858_/S _4802_/B VDD VSS sg13cmos5l_xnor2_1
X_7521_ _7562_/D _7619_/C VDD VSS sg13cmos5l_inv_1
X_4733_ _4792_/A _4716_/B _4716_/A _4732_/Y VDD VSS sg13cmos5l_a21o_1
XFILLER_119_18 VDD VSS sg13cmos5l_fill_2
X_7452_ _7589_/B _7452_/A _7585_/A VDD VSS sg13cmos5l_nand2_1
X_6403_ _6827_/A _7672_/Q _6403_/B VDD VSS sg13cmos5l_xnor2_1
X_4664_ _4665_/B _4721_/B _4721_/A VDD VSS sg13cmos5l_xor2_1
X_7383_ _7387_/B _7376_/A _7247_/Y _7382_/Y VDD VSS sg13cmos5l_o21ai_1
X_4595_ _4596_/B _4595_/A _4595_/B VDD VSS sg13cmos5l_xor2_1
X_6334_ _6336_/A _6334_/A _6630_/B VDD VSS sg13cmos5l_nor2_1
Xrebuffer1911 rebuffer1911/X rebuffer1912/X VDD VSS sg13cmos5l_buf_1
Xrebuffer1900 _4111_/B _4093_/A VDD VSS sg13cmos5l_buf_1
X_6265_ _6268_/A _6265_/A _6265_/B _6275_/A VDD VSS sg13cmos5l_nand3_1
Xrebuffer1955 rebuffer1955/X rebuffer1956/X VDD VSS sg13cmos5l_buf_1
Xrebuffer1944 rebuffer1944/X rebuffer1945/X VDD VSS sg13cmos5l_buf_1
Xrebuffer1933 rebuffer1933/X rebuffer1934/X VDD VSS sg13cmos5l_buf_1
Xrebuffer1922 rebuffer1922/X rebuffer1923/X VDD VSS sg13cmos5l_buf_1
X_5216_ _5238_/B _5286_/B _5216_/B VDD VSS sg13cmos5l_xnor2_1
Xrebuffer1988 rebuffer1988/X rebuffer1989/X VDD VSS sg13cmos5l_buf_1
Xrebuffer1977 rebuffer1977/X rebuffer1978/X VDD VSS sg13cmos5l_buf_1
Xrebuffer1966 rebuffer1966/X rebuffer1967/X VDD VSS sg13cmos5l_buf_1
X_6196_ _6196_/Y _6205_/A _6196_/B VDD VSS sg13cmos5l_nor2_1
XFILLER_28_15 VDD VSS sg13cmos5l_decap_4
XFILLER_57_646 VDD VSS sg13cmos5l_fill_2
Xrebuffer1999 rebuffer1999/X _4188_/A VDD VSS sg13cmos5l_buf_1
X_5147_ _5147_/Y _5147_/A _5147_/B VDD VSS sg13cmos5l_nor2_1
XFILLER_84_421 VDD VSS sg13cmos5l_fill_1
XFILLER_56_145 VDD VSS sg13cmos5l_decap_8
X_5078_ _5078_/Y _5078_/A _5078_/B VDD VSS sg13cmos5l_nor2_1
XFILLER_44_307 VDD VSS sg13cmos5l_decap_4
XFILLER_72_627 VDD VSS sg13cmos5l_decap_8
X_4029_ _4030_/B _4156_/A1 _4175_/A2 wire989/X _4175_/B2 VDD VSS sg13cmos5l_a22oi_1
XFILLER_65_690 VDD VSS sg13cmos5l_decap_8
XFILLER_71_148 VDD VSS sg13cmos5l_decap_4
XFILLER_53_874 VDD VSS sg13cmos5l_decap_8
X_7719_ _7719_/Q _7720_/CLK _7719_/D place745/X VDD VSS sg13cmos5l_dfrbpq_1
XFILLER_121_4 VDD VSS sg13cmos5l_decap_8
XFILLER_69_44 VDD VSS sg13cmos5l_fill_2
XFILLER_79_204 VDD VSS sg13cmos5l_fill_1
XFILLER_48_613 VDD VSS sg13cmos5l_decap_4
XFILLER_85_65 VDD VSS sg13cmos5l_fill_2
Xplace605 _5981_/A2 _4203_/A VDD VSS sg13cmos5l_buf_1
XFILLER_44_841 VDD VSS sg13cmos5l_decap_8
XFILLER_62_148 VDD VSS sg13cmos5l_decap_8
Xplace616 _5927_/A _5546_/A VDD VSS sg13cmos5l_buf_1
Xplace627 _4525_/B _4447_/B VDD VSS sg13cmos5l_buf_1
Xplace638 _4799_/B1 wire982/X VDD VSS sg13cmos5l_buf_1
XFILLER_71_660 VDD VSS sg13cmos5l_decap_4
Xplace649 _5760_/B1 _5076_/A VDD VSS sg13cmos5l_buf_1
XFILLER_70_170 VDD VSS sg13cmos5l_fill_2
XFILLER_71_682 VDD VSS sg13cmos5l_fill_1
X_4380_ _4381_/B _4426_/A _4426_/B VDD VSS sg13cmos5l_xor2_1
X_6050_ _6093_/B _6031_/B _6031_/A _6049_/X VDD VSS sg13cmos5l_a21o_1
X_5001_ _5002_/B _5557_/B1 _5322_/A2 _5066_/A1 _5322_/B2 VDD VSS sg13cmos5l_a22oi_1
XFILLER_38_134 VDD VSS sg13cmos5l_fill_1
XFILLER_78_292 VDD VSS sg13cmos5l_decap_4
X_6952_ _6953_/A _6944_/Y _7184_/B _6951_/Y VDD VSS sg13cmos5l_a21oi_1
XFILLER_62_660 VDD VSS sg13cmos5l_fill_1
X_6883_ _6883_/Y _6883_/A _6883_/B VDD VSS sg13cmos5l_xnor2_1
X_5903_ _5903_/Y _5945_/A _5904_/A VDD VSS sg13cmos5l_nor2_1
XFILLER_61_170 VDD VSS sg13cmos5l_decap_8
X_5834_ _5835_/A _5834_/A VDD VSS sg13cmos5l_inv_1
XFILLER_50_855 VDD VSS sg13cmos5l_decap_8
XFILLER_61_192 VDD VSS sg13cmos5l_decap_8
X_5765_ _5797_/B _5977_/B _5765_/B VDD VSS sg13cmos5l_xnor2_1
X_7504_ _7504_/Y _7504_/A1 _7506_/A _7381_/B VDD VSS sg13cmos5l_a21oi_1
X_5696_ _5697_/B _5949_/B1 _5981_/A2 _5909_/B1 _5981_/B2 VDD VSS sg13cmos5l_a22oi_1
X_4716_ _4717_/B _4716_/A _4716_/B VDD VSS sg13cmos5l_xor2_1
X_7435_ _7436_/B _7472_/A1 _7130_/Y _7472_/B1 VDD VSS sg13cmos5l_o21ai_1
X_4647_ _4648_/B _4947_/A _4767_/B _4647_/C VDD VSS sg13cmos5l_nor3_1
X_6317_ _6317_/Y _7664_/Q _6317_/B _6328_/C VDD VSS sg13cmos5l_nand3_1
X_4578_ _4623_/B _4692_/A _4578_/B VDD VSS sg13cmos5l_xnor2_1
X_7297_ _7297_/Y _7297_/A _7297_/B VDD VSS sg13cmos5l_nor2_1
X_6248_ _6261_/B _6248_/A VDD VSS sg13cmos5l_inv_16
XFILLER_77_708 VDD VSS sg13cmos5l_decap_8
XFILLER_39_58 VDD VSS sg13cmos5l_fill_1
X_6179_ _6180_/B _6172_/B _6172_/A _6178_/Y VDD VSS sg13cmos5l_a21oi_1
XFILLER_85_730 VDD VSS sg13cmos5l_decap_8
XFILLER_57_432 VDD VSS sg13cmos5l_fill_2
XFILLER_44_104 VDD VSS sg13cmos5l_fill_2
XFILLER_45_605 VDD VSS sg13cmos5l_fill_1
XFILLER_55_57 VDD VSS sg13cmos5l_fill_1
XFILLER_72_424 VDD VSS sg13cmos5l_fill_1
XFILLER_40_332 VDD VSS sg13cmos5l_decap_4
XFILLER_41_866 VDD VSS sg13cmos5l_decap_8
XFILLER_52_192 VDD VSS sg13cmos5l_fill_1
XFILLER_40_387 VDD VSS sg13cmos5l_fill_1
XFILLER_71_78 VDD VSS sg13cmos5l_decap_4
XFILLER_67_207 VDD VSS sg13cmos5l_fill_1
XFILLER_48_465 VDD VSS sg13cmos5l_fill_1
XFILLER_44_671 VDD VSS sg13cmos5l_fill_1
XFILLER_50_107 VDD VSS sg13cmos5l_decap_4
X_5550_ _5552_/C _5615_/B _5550_/B VDD VSS sg13cmos5l_xnor2_1
X_5481_ _5482_/B _5481_/A _5416_/A VDD VSS sg13cmos5l_nor2b_1
X_4501_ _4503_/A _4439_/B _4439_/A _4500_/X VDD VSS sg13cmos5l_a21oi_1
Xbank_A_sram.gen_ihp_256x32.u_sram_256x32_1207 bank_A_sram.gen_ihp_256x32.u_sram_256x32/A_DLY
+ VDD VSS sg13cmos5l_tiehi
X_7220_ _7369_/B _7276_/S _7220_/A2 _7219_/Y VDD VSS sg13cmos5l_o21ai_1
X_4432_ _4439_/A _4508_/A _4432_/B VDD VSS sg13cmos5l_xnor2_1
XFILLER_116_19 VDD VSS sg13cmos5l_fill_2
Xoutput869 bank_A_rdata[0] _3999_/B VDD VSS sg13cmos5l_buf_1
X_7151_ _7177_/A _7151_/A _7650_/A _7651_/B VDD VSS sg13cmos5l_nand3_1
X_4363_ _4416_/B _4492_/A _4363_/B VDD VSS sg13cmos5l_nor2_1
X_7082_ _7082_/Y _7082_/A _7082_/B VDD VSS sg13cmos5l_nand2_1
X_6102_ _6105_/A _6132_/B _6132_/A VDD VSS sg13cmos5l_xor2_1
X_4294_ _7670_/D _4294_/A _4294_/B VDD VSS sg13cmos5l_xnor2_1
X_6033_ _6068_/B _5994_/B _6033_/B VDD VSS sg13cmos5l_nand2b_1
XFILLER_86_549 VDD VSS sg13cmos5l_decap_8
XFILLER_86_538 VDD VSS sg13cmos5l_decap_4
XFILLER_67_730 VDD VSS sg13cmos5l_decap_8
Xbank_B_sram.gen_ihp_256x32.u_sram_256x32_1216 bank_B_sram.gen_ihp_256x32.u_sram_256x32/A_BM[7]
+ VDD VSS sg13cmos5l_tiehi
Xbank_B_sram.gen_ihp_256x32.u_sram_256x32_1227 bank_B_sram.gen_ihp_256x32.u_sram_256x32/A_BM[18]
+ VDD VSS sg13cmos5l_tiehi
Xbank_B_sram.gen_ihp_256x32.u_sram_256x32_1238 bank_B_sram.gen_ihp_256x32.u_sram_256x32/A_BM[29]
+ VDD VSS sg13cmos5l_tiehi
XFILLER_82_755 VDD VSS sg13cmos5l_decap_8
XFILLER_70_917 VDD VSS sg13cmos5l_fill_1
X_6935_ _6935_/X _7061_/A _7072_/B VDD VSS sg13cmos5l_and2_1
XFILLER_81_265 VDD VSS sg13cmos5l_fill_2
XFILLER_81_254 VDD VSS sg13cmos5l_decap_4
XFILLER_50_652 VDD VSS sg13cmos5l_decap_4
X_6866_ _6867_/A _6862_/X _6929_/B _6865_/Y VDD VSS sg13cmos5l_a21oi_2
X_6797_ _6797_/Y _6797_/A _6807_/A VDD VSS sg13cmos5l_nand2_1
X_5817_ _5817_/X _5817_/A _5817_/B VDD VSS sg13cmos5l_and2_1
X_5748_ _5751_/A _5791_/S _5748_/B VDD VSS sg13cmos5l_xnor2_1
X_5679_ _5727_/A _5679_/A _5679_/B VDD VSS sg13cmos5l_nand2_1
X_7418_ _7575_/A _7579_/B _7579_/A VDD VSS sg13cmos5l_nand2_2
Xrebuffer1560 rebuffer1560/X _6987_/A VDD VSS sg13cmos5l_buf_1
XFILLER_77_549 VDD VSS sg13cmos5l_decap_8
XFILLER_57_240 VDD VSS sg13cmos5l_fill_2
XFILLER_72_221 VDD VSS sg13cmos5l_decap_8
XFILLER_72_254 VDD VSS sg13cmos5l_decap_8
XFILLER_60_416 VDD VSS sg13cmos5l_decap_8
XFILLER_72_265 VDD VSS sg13cmos5l_decap_4
XFILLER_72_287 VDD VSS sg13cmos5l_decap_8
XFILLER_40_140 VDD VSS sg13cmos5l_decap_8
Xclkbuf_4_7_0_clk_i_regs clkload4/A clkbuf_0_clk_i_regs/X VDD VSS sg13cmos5l_buf_8
XFILLER_68_527 VDD VSS sg13cmos5l_fill_2
XFILLER_49_741 VDD VSS sg13cmos5l_decap_8
XFILLER_37_914 VDD VSS sg13cmos5l_decap_4
XFILLER_48_251 VDD VSS sg13cmos5l_fill_1
XFILLER_76_582 VDD VSS sg13cmos5l_fill_2
XFILLER_52_917 VDD VSS sg13cmos5l_fill_1
XFILLER_64_755 VDD VSS sg13cmos5l_fill_2
XFILLER_64_766 VDD VSS sg13cmos5l_decap_8
XFILLER_63_287 VDD VSS sg13cmos5l_fill_1
X_4981_ _5041_/B _5045_/A _4981_/B VDD VSS sg13cmos5l_nor2_1
X_6651_ _6652_/A _6660_/B _6660_/A VDD VSS sg13cmos5l_nor2_1
X_6582_ _6771_/A _7692_/Q _6582_/B VDD VSS sg13cmos5l_xnor2_1
X_5602_ _5603_/A _5533_/B _5533_/A _5601_/Y VDD VSS sg13cmos5l_a21o_1
X_5533_ _5534_/B _5533_/A _5533_/B VDD VSS sg13cmos5l_xor2_1
Xbank_A_sram.gen_ihp_256x32.u_sram_256x32_1026 bank_A_sram.gen_ihp_256x32.u_sram_256x32_1026/L_LO
+ VDD VSS sg13cmos5l_tielo
X_5464_ _5512_/B _5586_/A _5464_/B VDD VSS sg13cmos5l_xnor2_1
Xbank_A_sram.gen_ihp_256x32.u_sram_256x32_1037 bank_A_sram.gen_ihp_256x32.u_sram_256x32_1037/L_LO
+ VDD VSS sg13cmos5l_tielo
Xbank_A_sram.gen_ihp_256x32.u_sram_256x32_1048 bank_A_sram.gen_ihp_256x32.u_sram_256x32_1048/L_LO
+ VDD VSS sg13cmos5l_tielo
Xbank_A_sram.gen_ihp_256x32.u_sram_256x32_1059 bank_A_sram.gen_ihp_256x32.u_sram_256x32_1059/L_LO
+ VDD VSS sg13cmos5l_tielo
X_7203_ _7217_/A _7203_/A _7536_/B _7537_/B VDD VSS sg13cmos5l_nand3_1
X_5395_ _5396_/C _5395_/A VDD VSS sg13cmos5l_inv_1
X_4415_ _4481_/A _4407_/B _4407_/A _4414_/X VDD VSS sg13cmos5l_a21o_1
X_7134_ _7134_/Y _7134_/A _7134_/B VDD VSS sg13cmos5l_nand2_1
X_4346_ _4347_/A _4346_/A VDD VSS sg13cmos5l_inv_1
XFILLER_87_836 VDD VSS sg13cmos5l_decap_8
XFILLER_86_313 VDD VSS sg13cmos5l_fill_2
XFILLER_59_549 VDD VSS sg13cmos5l_fill_1
X_7065_ _7065_/X _7065_/A _7078_/B VDD VSS sg13cmos5l_and2_1
X_4277_ _4277_/Y _4277_/A _4277_/B VDD VSS sg13cmos5l_nor2_1
XFILLER_86_346 VDD VSS sg13cmos5l_fill_1
XFILLER_39_251 VDD VSS sg13cmos5l_fill_1
X_6016_ _6017_/B _6016_/A _6018_/B VDD VSS sg13cmos5l_nand2_1
XFILLER_43_906 VDD VSS sg13cmos5l_decap_8
XFILLER_43_917 VDD VSS sg13cmos5l_fill_1
XFILLER_82_563 VDD VSS sg13cmos5l_fill_1
XFILLER_54_287 VDD VSS sg13cmos5l_fill_1
XFILLER_70_736 VDD VSS sg13cmos5l_fill_2
X_6918_ _6918_/Y _6754_/Y _6918_/B VDD VSS sg13cmos5l_nand2b_1
X_6849_ _6849_/X _6849_/A _6968_/B VDD VSS sg13cmos5l_and2_1
XFILLER_78_814 VDD VSS sg13cmos5l_decap_8
XFILLER_77_346 VDD VSS sg13cmos5l_fill_2
Xrebuffer1390 rebuffer1390/X _7232_/A VDD VSS sg13cmos5l_buf_1
XFILLER_58_582 VDD VSS sg13cmos5l_decap_8
XFILLER_46_766 VDD VSS sg13cmos5l_fill_1
X_4200_ _6052_/A _4266_/A _4200_/B VDD VSS sg13cmos5l_nand2_1
XFILLER_69_836 VDD VSS sg13cmos5l_decap_8
X_5180_ _5181_/B _5432_/A _5180_/B VDD VSS sg13cmos5l_xnor2_1
X_4131_ _4132_/B _4056_/A _4175_/A2 _4023_/A _4175_/B2 VDD VSS sg13cmos5l_a22oi_1
X_4062_ _4063_/B _4062_/A _4079_/A VDD VSS sg13cmos5l_xor2_1
XFILLER_84_828 VDD VSS sg13cmos5l_decap_8
XFILLER_37_722 VDD VSS sg13cmos5l_fill_1
XFILLER_37_755 VDD VSS sg13cmos5l_decap_4
XFILLER_52_714 VDD VSS sg13cmos5l_fill_2
XFILLER_64_596 VDD VSS sg13cmos5l_decap_8
X_4964_ _4979_/A _4904_/B _4904_/A _4963_/X VDD VSS sg13cmos5l_a21o_1
X_6703_ _6703_/Y _6703_/A VDD VSS sg13cmos5l_inv_1
X_7683_ _7683_/Q clkload5/A _7683_/D place754/A VDD VSS sg13cmos5l_dfrbpq_1
X_4895_ _4896_/B _4895_/A _4895_/B VDD VSS sg13cmos5l_xor2_1
X_6634_ _6754_/A _7698_/Q _6634_/B VDD VSS sg13cmos5l_xnor2_1
X_6565_ _6567_/C _6611_/A _6611_/B _6565_/C VDD VSS sg13cmos5l_nand3_1
X_6496_ _6837_/B _6487_/B _7681_/Q VDD VSS sg13cmos5l_nand2b_1
X_5378_ _5378_/Y _5378_/A _5342_/B VDD VSS sg13cmos5l_nor2b_1
XFILLER_87_622 VDD VSS sg13cmos5l_fill_1
X_7117_ _7118_/B _7195_/B _7264_/B _7116_/Y VDD VSS sg13cmos5l_o21ai_1
X_4329_ _4382_/A _4447_/B _4275_/A _4328_/Y VDD VSS sg13cmos5l_a21o_1
XFILLER_87_633 VDD VSS sg13cmos5l_decap_8
XFILLER_86_121 VDD VSS sg13cmos5l_fill_2
XFILLER_47_14 VDD VSS sg13cmos5l_fill_1
Xfanout189 _4871_/A _4690_/A VDD VSS sg13cmos5l_buf_1
X_7048_ _7484_/B _7483_/B VDD VSS sg13cmos5l_inv_2
XFILLER_75_828 VDD VSS sg13cmos5l_decap_8
XFILLER_47_47 VDD VSS sg13cmos5l_fill_1
XFILLER_68_880 VDD VSS sg13cmos5l_decap_8
XFILLER_103_20 VDD VSS sg13cmos5l_fill_1
XFILLER_43_703 VDD VSS sg13cmos5l_decap_8
XFILLER_43_714 VDD VSS sg13cmos5l_fill_1
XFILLER_83_894 VDD VSS sg13cmos5l_decap_8
XFILLER_82_360 VDD VSS sg13cmos5l_decap_4
XFILLER_70_577 VDD VSS sg13cmos5l_decap_8
XFILLER_8_19 VDD VSS sg13cmos5l_fill_2
XFILLER_88_54 VDD VSS sg13cmos5l_fill_2
XFILLER_78_655 VDD VSS sg13cmos5l_decap_8
XFILLER_66_817 VDD VSS sg13cmos5l_decap_8
XFILLER_59_891 VDD VSS sg13cmos5l_decap_8
XFILLER_77_198 VDD VSS sg13cmos5l_decap_8
XFILLER_77_176 VDD VSS sg13cmos5l_fill_1
XFILLER_74_850 VDD VSS sg13cmos5l_decap_8
XFILLER_46_563 VDD VSS sg13cmos5l_fill_2
X_4680_ _4680_/X _4680_/A _4680_/B VDD VSS sg13cmos5l_and2_1
X_6350_ _6352_/A _6350_/A _6350_/B VDD VSS sg13cmos5l_nand2_2
X_5301_ _5357_/A _5301_/A _5294_/A VDD VSS sg13cmos5l_nor2b_1
X_6281_ _6586_/B _6611_/B _6448_/B VDD VSS sg13cmos5l_nand2_1
X_5232_ _5233_/B _5231_/B _5232_/B VDD VSS sg13cmos5l_nand2b_1
XFILLER_124_19 VDD VSS sg13cmos5l_fill_2
XFILLER_38_0 VDD VSS sg13cmos5l_fill_2
X_5163_ _5173_/A _5095_/B _5095_/A _5162_/X VDD VSS sg13cmos5l_a21o_1
XFILLER_68_154 VDD VSS sg13cmos5l_fill_2
XFILLER_69_688 VDD VSS sg13cmos5l_fill_2
X_4114_ _5977_/A _4207_/A _4114_/B VDD VSS sg13cmos5l_nand2_1
XFILLER_56_316 VDD VSS sg13cmos5l_decap_8
XFILLER_57_839 VDD VSS sg13cmos5l_decap_8
XFILLER_69_699 VDD VSS sg13cmos5l_fill_1
X_5094_ _5095_/B _5162_/B _5162_/A VDD VSS sg13cmos5l_xor2_1
XFILLER_84_625 VDD VSS sg13cmos5l_decap_8
XFILLER_83_124 VDD VSS sg13cmos5l_decap_8
XFILLER_83_113 VDD VSS sg13cmos5l_fill_2
XFILLER_56_349 VDD VSS sg13cmos5l_fill_2
XFILLER_65_850 VDD VSS sg13cmos5l_decap_8
XFILLER_72_809 VDD VSS sg13cmos5l_decap_8
X_4045_ _4045_/Y _5898_/B _5897_/A VDD VSS sg13cmos5l_nor2b_1
XFILLER_83_146 VDD VSS sg13cmos5l_decap_4
XFILLER_52_511 VDD VSS sg13cmos5l_fill_2
XFILLER_64_360 VDD VSS sg13cmos5l_fill_2
XFILLER_52_522 VDD VSS sg13cmos5l_fill_1
X_5996_ _5997_/A _6036_/A _5996_/B VDD VSS sg13cmos5l_xnor2_1
XFILLER_80_864 VDD VSS sg13cmos5l_decap_8
X_4947_ _4948_/B _4947_/A _4947_/B _4947_/C VDD VSS sg13cmos5l_nor3_1
X_7666_ _7666_/Q _7720_/CLK _7666_/D place747/X VDD VSS sg13cmos5l_dfrbpq_1
X_4878_ _4879_/B _4878_/A1 _4878_/A2 _4930_/A1 _4878_/B2 VDD VSS sg13cmos5l_a22oi_1
X_6617_ _6756_/A _7696_/Q _6617_/B VDD VSS sg13cmos5l_xnor2_1
X_7597_ _7599_/A _7597_/A _7597_/B VDD VSS sg13cmos5l_nand2_1
X_6548_ _6560_/A _6927_/B _6548_/B _6548_/C _6548_/D VDD VSS sg13cmos5l_nor4_1
X_6479_ _6841_/A _7680_/Q _6479_/B VDD VSS sg13cmos5l_xnor2_1
XFILLER_58_46 VDD VSS sg13cmos5l_fill_1
XFILLER_48_828 VDD VSS sg13cmos5l_decap_8
XFILLER_58_57 VDD VSS sg13cmos5l_decap_4
XFILLER_59_143 VDD VSS sg13cmos5l_fill_1
XFILLER_59_154 VDD VSS sg13cmos5l_fill_1
Xwire1002 _4562_/B1 wire1002/A VDD VSS sg13cmos5l_buf_2
XFILLER_87_463 VDD VSS sg13cmos5l_fill_1
XFILLER_74_102 VDD VSS sg13cmos5l_fill_1
Xinput758 input758/X bank_A_addr[3] VDD VSS sg13cmos5l_buf_1
Xinput769 input769/X bank_A_wdata[15] VDD VSS sg13cmos5l_buf_1
XFILLER_74_124 VDD VSS sg13cmos5l_fill_1
XFILLER_56_861 VDD VSS sg13cmos5l_decap_8
XFILLER_55_382 VDD VSS sg13cmos5l_decap_8
XFILLER_83_691 VDD VSS sg13cmos5l_decap_8
XFILLER_43_566 VDD VSS sg13cmos5l_fill_1
XFILLER_71_886 VDD VSS sg13cmos5l_decap_8
XFILLER_43_588 VDD VSS sg13cmos5l_decap_4
XFILLER_99_20 VDD VSS sg13cmos5l_fill_1
XFILLER_39_806 VDD VSS sg13cmos5l_decap_8
XFILLER_65_102 VDD VSS sg13cmos5l_decap_8
XFILLER_38_349 VDD VSS sg13cmos5l_fill_2
XFILLER_48_90 VDD VSS sg13cmos5l_decap_8
XFILLER_47_872 VDD VSS sg13cmos5l_decap_8
XFILLER_65_157 VDD VSS sg13cmos5l_decap_4
XFILLER_62_831 VDD VSS sg13cmos5l_decap_8
XFILLER_61_352 VDD VSS sg13cmos5l_decap_8
X_5850_ _5851_/B _5824_/B _5850_/B VDD VSS sg13cmos5l_nand2b_1
X_4801_ _4802_/B _4988_/A _4801_/B VDD VSS sg13cmos5l_xnor2_1
X_7520_ _7619_/C _7520_/A _7520_/B VDD VSS sg13cmos5l_xor2_1
X_4732_ _4732_/Y _4732_/A _4717_/B VDD VSS sg13cmos5l_nor2b_1
X_7451_ _7453_/B _7460_/A _7451_/B VDD VSS sg13cmos5l_xnor2_1
X_4663_ _4721_/A _4604_/B _4604_/A _4662_/X VDD VSS sg13cmos5l_a21o_1
X_6402_ _6403_/B _6410_/A _6401_/Y _6450_/A2 VDD VSS sg13cmos5l_o21ai_1
X_7382_ _7382_/Y _7253_/Y _7405_/A2 _7377_/B VDD VSS sg13cmos5l_a21oi_1
X_4594_ _4595_/B _4638_/A _4638_/B VDD VSS sg13cmos5l_xor2_1
X_6333_ _6630_/B _6376_/A _6979_/B _6499_/C VDD VSS sg13cmos5l_nand3_1
Xrebuffer1912 rebuffer1912/X rebuffer1913/X VDD VSS sg13cmos5l_buf_1
Xrebuffer1901 _5236_/B _5298_/A VDD VSS sg13cmos5l_buf_1
X_6264_ _6265_/B _6291_/A _6264_/B VDD VSS sg13cmos5l_nor2_2
Xrebuffer1945 rebuffer1945/X rebuffer1946/X VDD VSS sg13cmos5l_buf_1
Xrebuffer1934 rebuffer1934/X rebuffer1935/X VDD VSS sg13cmos5l_buf_1
Xrebuffer1923 rebuffer1923/X rebuffer1924/X VDD VSS sg13cmos5l_buf_1
X_5215_ _5216_/B _5215_/A _5287_/B VDD VSS sg13cmos5l_xor2_1
XFILLER_88_238 VDD VSS sg13cmos5l_fill_1
Xrebuffer1989 rebuffer1989/X rebuffer1990/X VDD VSS sg13cmos5l_buf_1
Xrebuffer1978 rebuffer1978/X rebuffer1979/X VDD VSS sg13cmos5l_buf_1
Xrebuffer1967 rebuffer1967/X rebuffer1968/X VDD VSS sg13cmos5l_buf_1
Xrebuffer1956 rebuffer1956/X rebuffer1957/X VDD VSS sg13cmos5l_buf_1
X_6195_ _6195_/Y _6195_/A VDD VSS sg13cmos5l_inv_1
XFILLER_85_912 VDD VSS sg13cmos5l_decap_4
XFILLER_56_113 VDD VSS sg13cmos5l_decap_8
X_5146_ _5147_/B _5460_/A _5206_/B _5146_/C VDD VSS sg13cmos5l_nor3_1
XFILLER_56_135 VDD VSS sg13cmos5l_fill_2
X_5077_ _5078_/B _5460_/A _5206_/B _5077_/C VDD VSS sg13cmos5l_nor3_1
XFILLER_71_127 VDD VSS sg13cmos5l_decap_8
XFILLER_53_853 VDD VSS sg13cmos5l_decap_8
X_5979_ _6025_/B _5977_/B _6111_/A _5977_/Y _5978_/Y VDD VSS sg13cmos5l_a22oi_1
X_7718_ _7718_/Q clkload0/A _7718_/D place750/X VDD VSS sg13cmos5l_dfrbpq_1
XFILLER_60_69 VDD VSS sg13cmos5l_fill_1
X_7649_ _7725_/D _7649_/A _7658_/B VDD VSS sg13cmos5l_nand2_2
XFILLER_114_4 VDD VSS sg13cmos5l_decap_8
XFILLER_75_411 VDD VSS sg13cmos5l_fill_1
XFILLER_48_647 VDD VSS sg13cmos5l_fill_2
XFILLER_87_293 VDD VSS sg13cmos5l_decap_8
XFILLER_85_77 VDD VSS sg13cmos5l_fill_1
XFILLER_75_455 VDD VSS sg13cmos5l_fill_1
XFILLER_75_433 VDD VSS sg13cmos5l_decap_8
XFILLER_44_820 VDD VSS sg13cmos5l_decap_8
Xplace606 _5385_/B2 _5871_/B2 VDD VSS sg13cmos5l_buf_1
Xplace617 _5546_/A _5045_/A VDD VSS sg13cmos5l_buf_1
Xplace628 _4447_/B _5335_/B VDD VSS sg13cmos5l_buf_1
Xplace639 _4738_/B1 wire984/X VDD VSS sg13cmos5l_buf_1
XFILLER_44_897 VDD VSS sg13cmos5l_decap_8
XFILLER_38_102 VDD VSS sg13cmos5l_fill_2
XFILLER_38_113 VDD VSS sg13cmos5l_fill_1
XFILLER_78_282 VDD VSS sg13cmos5l_decap_4
XFILLER_53_116 VDD VSS sg13cmos5l_decap_8
X_6951_ _6951_/Y _6951_/A _7138_/A VDD VSS sg13cmos5l_nor2_1
XFILLER_81_447 VDD VSS sg13cmos5l_fill_2
X_6882_ _6882_/Y _6882_/A _6882_/B VDD VSS sg13cmos5l_xnor2_1
X_5902_ _5904_/A _5944_/A _5902_/B VDD VSS sg13cmos5l_xnor2_1
XFILLER_50_834 VDD VSS sg13cmos5l_decap_8
XFILLER_61_160 VDD VSS sg13cmos5l_fill_2
X_5833_ _5837_/C _5833_/A _5833_/B VDD VSS sg13cmos5l_nand2_1
X_7503_ _7573_/A _7503_/A _7503_/B VDD VSS sg13cmos5l_xor2_1
X_5764_ _5765_/B _5805_/B1 _4158_/Y _5801_/A1 _4160_/Y VDD VSS sg13cmos5l_a22oi_1
X_5695_ _5742_/A _5649_/B _5649_/A _5694_/Y VDD VSS sg13cmos5l_a21oi_1
X_4715_ _4716_/B _4715_/A _4715_/B VDD VSS sg13cmos5l_nand2_1
X_7434_ _7439_/A _7434_/A _7434_/B VDD VSS sg13cmos5l_nand2_2
X_4646_ _4647_/C _4646_/A VDD VSS sg13cmos5l_inv_1
X_7365_ _7368_/B _7380_/B _7374_/A VDD VSS sg13cmos5l_xnor2_1
X_4577_ _4578_/B _4986_/B1 _4878_/A2 _4800_/B1 _4878_/B2 VDD VSS sg13cmos5l_a22oi_1
X_6316_ _6318_/A _6317_/B _6328_/C _7664_/Q VDD VSS sg13cmos5l_a21oi_1
X_7296_ _7297_/B _7296_/A _7296_/B VDD VSS sg13cmos5l_nor2_1
XFILLER_39_37 VDD VSS sg13cmos5l_fill_2
X_6247_ _7274_/A _7712_/Q VDD VSS sg13cmos5l_inv_1
X_6178_ _6178_/Y _6178_/A _6169_/B VDD VSS sg13cmos5l_nor2b_1
X_5129_ _5130_/B _5430_/B1 _5380_/A2 _5370_/B1 _5188_/B2 VDD VSS sg13cmos5l_a22oi_1
XFILLER_73_915 VDD VSS sg13cmos5l_fill_2
XFILLER_85_786 VDD VSS sg13cmos5l_decap_8
XFILLER_40_311 VDD VSS sg13cmos5l_decap_8
XFILLER_41_845 VDD VSS sg13cmos5l_decap_8
XFILLER_80_491 VDD VSS sg13cmos5l_decap_8
XFILLER_105_0 VDD VSS sg13cmos5l_fill_2
XFILLER_68_709 VDD VSS sg13cmos5l_fill_2
XFILLER_64_904 VDD VSS sg13cmos5l_decap_8
XFILLER_75_285 VDD VSS sg13cmos5l_fill_1
XFILLER_44_683 VDD VSS sg13cmos5l_fill_2
X_5480_ _5483_/B _5480_/A _5480_/B VDD VSS sg13cmos5l_xnor2_1
X_4500_ _4500_/X _4500_/A _4500_/B VDD VSS sg13cmos5l_and2_1
XANTENNA_1 input756/X VDD VSS sg13cmos5l_antennanp
Xbank_A_sram.gen_ihp_256x32.u_sram_256x32_1208 bank_A_sram.gen_ihp_256x32.u_sram_256x32/A_MEN
+ VDD VSS sg13cmos5l_tiehi
X_4431_ _4432_/B _4620_/B1 _4203_/A _4565_/B1 _4686_/B2 VDD VSS sg13cmos5l_a22oi_1
X_7150_ _7651_/B _7150_/A _7717_/Q VDD VSS sg13cmos5l_nand2_1
X_4362_ _4492_/A _6110_/B VDD VSS sg13cmos5l_inv_1
X_7081_ _7081_/Y _7081_/A _7168_/B VDD VSS sg13cmos5l_nand2_1
X_6101_ _6132_/A _5966_/A _6072_/B _6100_/Y VDD VSS sg13cmos5l_o21ai_1
X_4293_ _4351_/B _4346_/A _4293_/B VDD VSS sg13cmos5l_xnor2_1
X_6032_ _6068_/A _6032_/A _6051_/A VDD VSS sg13cmos5l_xor2_1
XFILLER_86_517 VDD VSS sg13cmos5l_decap_8
XFILLER_67_753 VDD VSS sg13cmos5l_decap_8
Xbank_B_sram.gen_ihp_256x32.u_sram_256x32_1217 bank_B_sram.gen_ihp_256x32.u_sram_256x32/A_BM[8]
+ VDD VSS sg13cmos5l_tiehi
Xbank_B_sram.gen_ihp_256x32.u_sram_256x32_1228 bank_B_sram.gen_ihp_256x32.u_sram_256x32/A_BM[19]
+ VDD VSS sg13cmos5l_tiehi
Xbank_B_sram.gen_ihp_256x32.u_sram_256x32_1239 bank_B_sram.gen_ihp_256x32.u_sram_256x32/A_BM[30]
+ VDD VSS sg13cmos5l_tiehi
XFILLER_82_734 VDD VSS sg13cmos5l_decap_8
XFILLER_81_222 VDD VSS sg13cmos5l_decap_4
X_6934_ _7061_/A _6880_/Y _6883_/Y _6934_/S VDD VSS sg13cmos5l_mux2_1
XFILLER_81_233 VDD VSS sg13cmos5l_decap_8
XFILLER_50_631 VDD VSS sg13cmos5l_decap_8
X_6865_ _6865_/Y _6929_/B _6929_/A VDD VSS sg13cmos5l_nor2_2
XFILLER_50_675 VDD VSS sg13cmos5l_fill_1
XFILLER_50_686 VDD VSS sg13cmos5l_decap_4
X_5816_ _5855_/B _5816_/A _5816_/B VDD VSS sg13cmos5l_xor2_1
X_5747_ _5748_/B _5747_/A _5747_/B VDD VSS sg13cmos5l_xnor2_1
X_7417_ _7579_/A _7438_/A _7417_/B VDD VSS sg13cmos5l_xnor2_1
X_5678_ _5679_/B _5656_/A _5656_/B _5657_/A VDD VSS sg13cmos5l_o21ai_1
X_4629_ _4630_/B _4800_/B1 _4930_/A2 _4739_/B1 _4686_/B2 VDD VSS sg13cmos5l_a22oi_1
X_7348_ _7355_/A _7348_/A _7518_/B _7519_/B VDD VSS sg13cmos5l_nand3_1
X_7279_ _7279_/Y _7277_/Y _7278_/Y _7302_/A1 VDD VSS sg13cmos5l_a21oi_1
XFILLER_77_528 VDD VSS sg13cmos5l_decap_8
XFILLER_66_35 VDD VSS sg13cmos5l_fill_2
XFILLER_46_904 VDD VSS sg13cmos5l_decap_8
XFILLER_58_797 VDD VSS sg13cmos5l_fill_1
XFILLER_85_583 VDD VSS sg13cmos5l_decap_8
XFILLER_61_907 VDD VSS sg13cmos5l_decap_8
XFILLER_73_789 VDD VSS sg13cmos5l_decap_8
XFILLER_41_686 VDD VSS sg13cmos5l_fill_1
XFILLER_48_230 VDD VSS sg13cmos5l_fill_1
XFILLER_49_775 VDD VSS sg13cmos5l_decap_8
XFILLER_64_745 VDD VSS sg13cmos5l_fill_2
X_4980_ _5040_/B _4980_/A _4980_/B VDD VSS sg13cmos5l_nand2_1
X_6650_ _6660_/A _6646_/Y _6656_/A _6641_/C VDD VSS sg13cmos5l_o21ai_1
X_6581_ _6582_/B _6578_/Y _6588_/A _6598_/C VDD VSS sg13cmos5l_o21ai_1
X_5601_ _5601_/Y _5601_/A _5534_/B VDD VSS sg13cmos5l_nor2b_1
X_5532_ _5533_/B _5532_/A _5532_/B VDD VSS sg13cmos5l_nand2_1
X_5463_ _5464_/B _5641_/B1 _5585_/A2 _5274_/A _5585_/B2 VDD VSS sg13cmos5l_a22oi_1
Xbank_A_sram.gen_ihp_256x32.u_sram_256x32_1027 bank_A_sram.gen_ihp_256x32.u_sram_256x32_1027/L_LO
+ VDD VSS sg13cmos5l_tielo
Xbank_A_sram.gen_ihp_256x32.u_sram_256x32_1038 bank_A_sram.gen_ihp_256x32.u_sram_256x32_1038/L_LO
+ VDD VSS sg13cmos5l_tielo
Xbank_A_sram.gen_ihp_256x32.u_sram_256x32_1049 bank_A_sram.gen_ihp_256x32.u_sram_256x32_1049/L_LO
+ VDD VSS sg13cmos5l_tielo
X_7202_ _7537_/B _7175_/B _7719_/Q VDD VSS sg13cmos5l_nand2b_1
X_5394_ _5397_/A _5517_/A _5395_/A _5519_/B VDD VSS sg13cmos5l_a21oi_1
X_4414_ _4414_/X _4414_/A _4414_/B VDD VSS sg13cmos5l_and2_1
X_7133_ _7294_/A _7191_/B _7133_/A2 _7132_/Y VDD VSS sg13cmos5l_o21ai_1
X_4345_ _4354_/B _4345_/A _4292_/A VDD VSS sg13cmos5l_nor2b_1
XFILLER_87_815 VDD VSS sg13cmos5l_decap_8
X_4276_ _4277_/B _4447_/A _4447_/B _4276_/C VDD VSS sg13cmos5l_nor3_1
X_6015_ _6018_/B _6015_/A _6015_/B VDD VSS sg13cmos5l_nand2_1
XFILLER_55_734 VDD VSS sg13cmos5l_decap_8
XFILLER_82_520 VDD VSS sg13cmos5l_decap_8
XFILLER_54_244 VDD VSS sg13cmos5l_decap_8
XFILLER_82_531 VDD VSS sg13cmos5l_fill_1
XFILLER_54_255 VDD VSS sg13cmos5l_fill_1
XFILLER_70_726 VDD VSS sg13cmos5l_decap_8
XFILLER_52_15 VDD VSS sg13cmos5l_fill_2
X_6917_ _6917_/Y _6915_/Y _6917_/B VDD VSS sg13cmos5l_nand2b_1
X_6848_ _6849_/A _6848_/A _6848_/B VDD VSS sg13cmos5l_xor2_1
X_6779_ _6899_/B _6779_/A _6779_/B VDD VSS sg13cmos5l_nand2_2
Xrebuffer1380 rebuffer1380/X rebuffer1381/X VDD VSS sg13cmos5l_buf_1
Xrebuffer1391 _6238_/A _6255_/A VDD VSS sg13cmos5l_buf_1
XFILLER_46_723 VDD VSS sg13cmos5l_decap_8
XFILLER_86_892 VDD VSS sg13cmos5l_decap_8
XFILLER_45_233 VDD VSS sg13cmos5l_decap_8
XFILLER_46_745 VDD VSS sg13cmos5l_fill_1
XFILLER_60_214 VDD VSS sg13cmos5l_fill_1
XFILLER_3_20 VDD VSS sg13cmos5l_fill_1
XFILLER_69_815 VDD VSS sg13cmos5l_decap_8
X_4130_ _4165_/A _4172_/B _4800_/B1 _4129_/Y VDD VSS sg13cmos5l_a21o_1
XFILLER_68_347 VDD VSS sg13cmos5l_fill_1
XFILLER_49_561 VDD VSS sg13cmos5l_decap_8
X_4061_ _4062_/A _4176_/A _4061_/B VDD VSS sg13cmos5l_xnor2_1
XFILLER_84_807 VDD VSS sg13cmos5l_decap_8
XFILLER_37_712 VDD VSS sg13cmos5l_fill_2
XFILLER_49_572 VDD VSS sg13cmos5l_fill_1
XFILLER_37_778 VDD VSS sg13cmos5l_decap_4
X_4963_ _4963_/X _4963_/A _4963_/B VDD VSS sg13cmos5l_and2_1
XFILLER_51_247 VDD VSS sg13cmos5l_fill_2
XFILLER_51_258 VDD VSS sg13cmos5l_fill_2
X_7682_ _7682_/Q _7712_/CLK _7682_/D place750/X VDD VSS sg13cmos5l_dfrbpq_1
X_6702_ _6702_/Y _6702_/A VDD VSS sg13cmos5l_inv_1
X_6633_ _6634_/B _6647_/A _6632_/Y _6641_/C VDD VSS sg13cmos5l_o21ai_1
X_4894_ _4895_/B _4939_/A _4939_/B VDD VSS sg13cmos5l_xor2_1
X_6564_ _6573_/A _6564_/A _6860_/B _6861_/B VDD VSS sg13cmos5l_nand3_1
X_6495_ _6836_/A _6495_/A VDD VSS sg13cmos5l_inv_1
X_5515_ _5525_/A _5757_/A _5515_/B VDD VSS sg13cmos5l_xnor2_1
X_5377_ _5471_/B _5377_/A _5377_/B VDD VSS sg13cmos5l_xor2_1
XFILLER_59_336 VDD VSS sg13cmos5l_fill_1
X_7116_ _7116_/Y _7114_/Y _7115_/Y _7327_/A VDD VSS sg13cmos5l_a21oi_1
X_4328_ _4328_/Y _4328_/A _4328_/B VDD VSS sg13cmos5l_nor2_1
XFILLER_74_306 VDD VSS sg13cmos5l_decap_8
X_7047_ _7047_/Y _7046_/B _6903_/Y _7046_/Y VDD VSS sg13cmos5l_o21ai_1
XFILLER_87_689 VDD VSS sg13cmos5l_decap_8
XFILLER_75_807 VDD VSS sg13cmos5l_decap_8
XFILLER_83_873 VDD VSS sg13cmos5l_decap_8
XFILLER_42_247 VDD VSS sg13cmos5l_fill_1
XFILLER_63_69 VDD VSS sg13cmos5l_decap_8
XFILLER_59_870 VDD VSS sg13cmos5l_decap_8
XFILLER_37_70 VDD VSS sg13cmos5l_decap_4
XFILLER_42_781 VDD VSS sg13cmos5l_decap_8
X_5300_ _7686_/D _5360_/B _5360_/A VDD VSS sg13cmos5l_xor2_1
X_6280_ _6448_/B _6407_/B _6499_/C _6517_/C VDD VSS sg13cmos5l_nor3_1
X_5231_ _5233_/A _5232_/B _5231_/B VDD VSS sg13cmos5l_nand2b_1
XFILLER_68_122 VDD VSS sg13cmos5l_decap_8
XFILLER_69_623 VDD VSS sg13cmos5l_fill_1
X_5162_ _5162_/X _5162_/A _5162_/B VDD VSS sg13cmos5l_and2_1
XFILLER_57_818 VDD VSS sg13cmos5l_decap_8
XFILLER_69_656 VDD VSS sg13cmos5l_decap_8
X_5093_ _5162_/A _5091_/Y _5024_/B _5092_/Y VDD VSS sg13cmos5l_o21ai_1
X_4113_ _5978_/B _4113_/A _4114_/B VDD VSS sg13cmos5l_nor2_1
XFILLER_84_604 VDD VSS sg13cmos5l_decap_8
XFILLER_17_18 VDD VSS sg13cmos5l_fill_2
XFILLER_37_531 VDD VSS sg13cmos5l_decap_4
X_4044_ _5897_/A _4322_/A _4044_/B VDD VSS sg13cmos5l_nand2_1
XFILLER_64_372 VDD VSS sg13cmos5l_fill_2
XFILLER_80_843 VDD VSS sg13cmos5l_decap_8
XFILLER_52_567 VDD VSS sg13cmos5l_decap_8
X_5995_ _5996_/B _6037_/A _6037_/B VDD VSS sg13cmos5l_xor2_1
XFILLER_40_729 VDD VSS sg13cmos5l_fill_2
X_4946_ _4947_/C _4946_/A VDD VSS sg13cmos5l_inv_1
X_7665_ _7665_/Q _7720_/CLK _7665_/D place747/X VDD VSS sg13cmos5l_dfrbpq_1
X_7596_ _7600_/A _7626_/A _7596_/B _7629_/C VDD VSS sg13cmos5l_nor3_2
X_6616_ _6617_/B _6612_/Y _6623_/A _6598_/C VDD VSS sg13cmos5l_o21ai_1
X_6547_ _6555_/A _6547_/A _6869_/A _6870_/B VDD VSS sg13cmos5l_nand3_1
XFILLER_116_8 VDD VSS sg13cmos5l_decap_8
X_6478_ _6479_/B _6475_/Y _6485_/B _6461_/C VDD VSS sg13cmos5l_o21ai_1
X_5429_ _5437_/A _5373_/B _5302_/A _5429_/S VDD VSS sg13cmos5l_mux2_1
XFILLER_79_409 VDD VSS sg13cmos5l_decap_8
Xwire1003 _4766_/A wire1003/A VDD VSS sg13cmos5l_buf_2
Xwire1014 _4642_/B1 wire1014/A VDD VSS sg13cmos5l_buf_2
XFILLER_114_20 VDD VSS sg13cmos5l_fill_1
Xinput759 input759/X bank_A_addr[4] VDD VSS sg13cmos5l_buf_1
XFILLER_75_637 VDD VSS sg13cmos5l_decap_8
XFILLER_56_840 VDD VSS sg13cmos5l_decap_8
XFILLER_75_659 VDD VSS sg13cmos5l_decap_8
XFILLER_55_361 VDD VSS sg13cmos5l_fill_1
XFILLER_83_670 VDD VSS sg13cmos5l_decap_8
XFILLER_71_865 VDD VSS sg13cmos5l_decap_8
XFILLER_79_910 VDD VSS sg13cmos5l_decap_8
XFILLER_38_306 VDD VSS sg13cmos5l_fill_1
XFILLER_47_851 VDD VSS sg13cmos5l_decap_8
XFILLER_62_810 VDD VSS sg13cmos5l_decap_8
X_4800_ _4801_/B _4986_/B1 _5179_/A2 _4800_/B1 _4800_/B2 VDD VSS sg13cmos5l_a22oi_1
XFILLER_62_887 VDD VSS sg13cmos5l_decap_8
X_5780_ _5845_/B _5780_/A _5780_/B VDD VSS sg13cmos5l_xnor2_1
X_4731_ _4784_/A _4731_/A _4720_/A VDD VSS sg13cmos5l_nor2b_1
X_7450_ _7451_/B _7211_/Y _7397_/A _7399_/A VDD VSS sg13cmos5l_a21o_1
X_4662_ _4662_/X _4662_/A _4662_/B VDD VSS sg13cmos5l_and2_1
X_6401_ _6401_/Y _6401_/A _6401_/B VDD VSS sg13cmos5l_nor2_1
X_7381_ _7386_/A _7381_/A _7381_/B _7506_/A VDD VSS sg13cmos5l_nand3_1
X_4593_ _4638_/B _5018_/A _4593_/B VDD VSS sg13cmos5l_xnor2_1
XFILLER_50_0 VDD VSS sg13cmos5l_fill_2
X_6332_ _6334_/A _6332_/A VDD VSS sg13cmos5l_inv_1
Xrebuffer1902 _4353_/A _4349_/Y VDD VSS sg13cmos5l_buf_1
X_6263_ _6264_/B _6279_/A _6407_/B _6533_/B VDD VSS sg13cmos5l_nand3_1
Xrebuffer1946 rebuffer1946/X rebuffer1947/X VDD VSS sg13cmos5l_buf_1
Xrebuffer1935 rebuffer1935/X rebuffer1936/X VDD VSS sg13cmos5l_buf_1
Xrebuffer1924 rebuffer1924/X rebuffer1925/X VDD VSS sg13cmos5l_buf_1
Xrebuffer1913 rebuffer1913/X rebuffer1914/X VDD VSS sg13cmos5l_buf_1
X_5214_ _5287_/B _5214_/A _5214_/B VDD VSS sg13cmos5l_xor2_1
Xrebuffer1979 rebuffer1979/X rebuffer1980/X VDD VSS sg13cmos5l_buf_1
Xrebuffer1968 rebuffer1968/X rebuffer1969/X VDD VSS sg13cmos5l_buf_1
Xrebuffer1957 rebuffer1957/X rebuffer1958/X VDD VSS sg13cmos5l_buf_1
X_6194_ _6194_/Y _6209_/A1 _6192_/Y _6193_/Y VDD VSS sg13cmos5l_a21oi_1
X_5145_ _5146_/C _5145_/A VDD VSS sg13cmos5l_inv_1
X_5076_ _5077_/C _5076_/A VDD VSS sg13cmos5l_inv_1
XFILLER_38_884 VDD VSS sg13cmos5l_decap_8
X_4027_ _4176_/A _5645_/A VDD VSS sg13cmos5l_inv_1
XFILLER_53_832 VDD VSS sg13cmos5l_decap_8
XFILLER_52_375 VDD VSS sg13cmos5l_decap_8
X_5978_ _5978_/Y _6111_/A _5978_/B VDD VSS sg13cmos5l_nor2_1
XFILLER_80_684 VDD VSS sg13cmos5l_decap_8
X_7717_ _7717_/Q clkload2/A _7717_/D place745/X VDD VSS sg13cmos5l_dfrbpq_1
X_4929_ _4956_/A _4897_/B _4897_/A _4928_/Y VDD VSS sg13cmos5l_a21oi_1
XFILLER_60_26 VDD VSS sg13cmos5l_fill_2
X_7648_ _7649_/A _7657_/A _7648_/B VDD VSS sg13cmos5l_nand2_2
X_7579_ _7623_/A _7579_/A _7579_/B VDD VSS sg13cmos5l_xor2_1
XFILLER_69_24 VDD VSS sg13cmos5l_decap_4
XFILLER_69_57 VDD VSS sg13cmos5l_fill_1
XFILLER_69_79 VDD VSS sg13cmos5l_decap_8
XFILLER_88_784 VDD VSS sg13cmos5l_fill_1
Xplace607 _5871_/B2 _4160_/Y VDD VSS sg13cmos5l_buf_1
Xplace618 _5018_/A _4532_/A VDD VSS sg13cmos5l_buf_1
Xplace629 _5206_/B _5460_/B VDD VSS sg13cmos5l_buf_1
XFILLER_43_331 VDD VSS sg13cmos5l_fill_1
XFILLER_44_876 VDD VSS sg13cmos5l_decap_8
XFILLER_43_364 VDD VSS sg13cmos5l_fill_2
XFILLER_70_150 VDD VSS sg13cmos5l_decap_8
XFILLER_70_161 VDD VSS sg13cmos5l_fill_1
XFILLER_70_172 VDD VSS sg13cmos5l_fill_1
XFILLER_50_81 VDD VSS sg13cmos5l_fill_1
XFILLER_67_902 VDD VSS sg13cmos5l_decap_8
XFILLER_39_604 VDD VSS sg13cmos5l_decap_4
XFILLER_39_626 VDD VSS sg13cmos5l_decap_8
XFILLER_79_784 VDD VSS sg13cmos5l_decap_8
XFILLER_66_434 VDD VSS sg13cmos5l_fill_1
XFILLER_54_607 VDD VSS sg13cmos5l_decap_4
X_6950_ _7138_/A _7065_/A _7082_/B _6949_/X VDD VSS sg13cmos5l_a21oi_1
XFILLER_82_916 VDD VSS sg13cmos5l_fill_2
XFILLER_81_404 VDD VSS sg13cmos5l_decap_4
X_5901_ _5902_/B _6084_/B1 _4158_/Y _5901_/B1 _4160_/Y VDD VSS sg13cmos5l_a22oi_1
X_6881_ _7032_/A _6879_/Y _6880_/Y _6941_/B VDD VSS sg13cmos5l_mux2_1
XFILLER_50_813 VDD VSS sg13cmos5l_decap_8
XFILLER_62_684 VDD VSS sg13cmos5l_fill_2
X_5832_ _5837_/B _5928_/A VDD VSS sg13cmos5l_inv_1
XFILLER_14_19 VDD VSS sg13cmos5l_fill_2
X_5763_ _5797_/A _5870_/A _5763_/B VDD VSS sg13cmos5l_xnor2_1
XFILLER_98_0 VDD VSS sg13cmos5l_fill_2
X_7502_ _7503_/B _7572_/A _7571_/A _7413_/A VDD VSS sg13cmos5l_o21ai_1
X_4714_ _4715_/B _4656_/A _4714_/B VDD VSS sg13cmos5l_nand2b_1
X_5694_ _5694_/Y _5694_/A _5694_/B VDD VSS sg13cmos5l_nor2_1
X_7433_ _7434_/B _7429_/B _7426_/B _7431_/B VDD VSS sg13cmos5l_a21o_1
X_4645_ _4648_/A _5012_/A1 _4646_/A _5012_/B1 VDD VSS sg13cmos5l_a21oi_1
X_7364_ _7374_/A _7289_/A _7211_/Y _7363_/Y VDD VSS sg13cmos5l_o21ai_1
X_4576_ _4623_/A _4871_/A _4576_/B VDD VSS sg13cmos5l_xnor2_1
X_6315_ _6317_/B _6324_/B _6324_/A VDD VSS sg13cmos5l_xnor2_1
X_7295_ _7295_/Y _7129_/B _7276_/S _7294_/X VDD VSS sg13cmos5l_a21oi_1
XFILLER_58_902 VDD VSS sg13cmos5l_decap_8
X_6177_ _6180_/A _6177_/A _6177_/B VDD VSS sg13cmos5l_xnor2_1
XFILLER_57_423 VDD VSS sg13cmos5l_fill_1
X_5128_ _5155_/A _5088_/B _5088_/A _5127_/Y VDD VSS sg13cmos5l_a21oi_1
XFILLER_72_404 VDD VSS sg13cmos5l_decap_4
XFILLER_85_765 VDD VSS sg13cmos5l_decap_8
XFILLER_84_253 VDD VSS sg13cmos5l_fill_1
XFILLER_38_681 VDD VSS sg13cmos5l_decap_8
XFILLER_72_415 VDD VSS sg13cmos5l_decap_8
X_5059_ _5089_/A _5022_/B _5022_/A _5058_/Y VDD VSS sg13cmos5l_a21oi_1
XFILLER_37_191 VDD VSS sg13cmos5l_fill_1
XFILLER_41_824 VDD VSS sg13cmos5l_decap_8
XFILLER_49_913 VDD VSS sg13cmos5l_decap_4
XFILLER_88_570 VDD VSS sg13cmos5l_fill_1
XFILLER_76_798 VDD VSS sg13cmos5l_decap_8
XANTENNA_2 _6188_/Y VDD VSS sg13cmos5l_antennanp
XFILLER_6_20 VDD VSS sg13cmos5l_fill_1
X_6100_ _6100_/Y _6100_/A _6100_/B VDD VSS sg13cmos5l_nand2_1
X_4361_ _6110_/B quant_cfg[13] VDD VSS sg13cmos5l_buf_1
X_4292_ _4346_/A _4292_/A _4345_/A VDD VSS sg13cmos5l_xnor2_1
X_6031_ _6051_/A _6031_/A _6031_/B VDD VSS sg13cmos5l_xnor2_1
Xbank_B_sram.gen_ihp_256x32.u_sram_256x32_1218 bank_B_sram.gen_ihp_256x32.u_sram_256x32/A_BM[9]
+ VDD VSS sg13cmos5l_tiehi
Xbank_B_sram.gen_ihp_256x32.u_sram_256x32_1229 bank_B_sram.gen_ihp_256x32.u_sram_256x32/A_BM[20]
+ VDD VSS sg13cmos5l_tiehi
XFILLER_79_592 VDD VSS sg13cmos5l_fill_2
XFILLER_39_467 VDD VSS sg13cmos5l_decap_8
XFILLER_55_916 VDD VSS sg13cmos5l_fill_2
XFILLER_67_776 VDD VSS sg13cmos5l_decap_8
XFILLER_82_713 VDD VSS sg13cmos5l_decap_8
X_6933_ _7072_/A _6882_/Y _6874_/B _6934_/S VDD VSS sg13cmos5l_mux2_1
X_6864_ _6929_/A _6864_/A _6861_/A VDD VSS sg13cmos5l_nor2b_2
X_5815_ _5816_/B _5876_/B _5876_/A VDD VSS sg13cmos5l_xor2_1
X_6795_ _6797_/A _7082_/B _6789_/Y _6794_/Y VDD VSS sg13cmos5l_o21ai_1
X_5746_ _5747_/B _5909_/B1 _4301_/Y _5859_/B1 _4365_/Y VDD VSS sg13cmos5l_a22oi_1
X_5677_ _5679_/A _5658_/A _5677_/B VDD VSS sg13cmos5l_nand2b_1
X_7416_ _7417_/B _7376_/A _7312_/Y _7399_/Y VDD VSS sg13cmos5l_o21ai_1
X_4628_ _4656_/A _4597_/B _4597_/A _4627_/Y VDD VSS sg13cmos5l_a21oi_1
X_7347_ _7519_/B _7347_/A _7360_/B VDD VSS sg13cmos5l_nand2_1
X_4559_ _4662_/B _4557_/Y _4538_/B _4558_/Y VDD VSS sg13cmos5l_o21ai_1
X_7278_ _7278_/Y _7186_/A _7298_/A1 _7297_/A VDD VSS sg13cmos5l_a21oi_1
XFILLER_49_209 VDD VSS sg13cmos5l_decap_8
XFILLER_58_743 VDD VSS sg13cmos5l_decap_4
XFILLER_57_231 VDD VSS sg13cmos5l_fill_1
XFILLER_57_242 VDD VSS sg13cmos5l_fill_1
XFILLER_66_47 VDD VSS sg13cmos5l_decap_8
XFILLER_85_562 VDD VSS sg13cmos5l_decap_8
XFILLER_58_787 VDD VSS sg13cmos5l_fill_2
XFILLER_72_201 VDD VSS sg13cmos5l_fill_1
XFILLER_45_437 VDD VSS sg13cmos5l_fill_2
XFILLER_72_245 VDD VSS sg13cmos5l_fill_1
XFILLER_41_621 VDD VSS sg13cmos5l_decap_8
XFILLER_41_632 VDD VSS sg13cmos5l_fill_2
XFILLER_41_643 VDD VSS sg13cmos5l_decap_4
XFILLER_53_470 VDD VSS sg13cmos5l_decap_4
XFILLER_52_908 VDD VSS sg13cmos5l_decap_8
XFILLER_56_91 VDD VSS sg13cmos5l_decap_8
XFILLER_63_245 VDD VSS sg13cmos5l_decap_8
XFILLER_64_757 VDD VSS sg13cmos5l_fill_1
X_6580_ _6588_/A _6587_/B VDD VSS sg13cmos5l_inv_1
X_5600_ _5606_/B _5600_/A VDD VSS sg13cmos5l_inv_1
X_5531_ _5532_/B _5469_/A _5531_/B VDD VSS sg13cmos5l_nand2b_1
X_7201_ _7536_/B _7201_/A _7720_/Q VDD VSS sg13cmos5l_nand2_1
X_5462_ _5512_/A _5460_/B _6082_/A1 _5461_/Y VDD VSS sg13cmos5l_a21o_1
Xbank_A_sram.gen_ihp_256x32.u_sram_256x32_1028 bank_A_sram.gen_ihp_256x32.u_sram_256x32_1028/L_LO
+ VDD VSS sg13cmos5l_tielo
Xbank_A_sram.gen_ihp_256x32.u_sram_256x32_1039 bank_A_sram.gen_ihp_256x32.u_sram_256x32_1039/L_LO
+ VDD VSS sg13cmos5l_tielo
X_4413_ _7672_/D _4475_/B _4413_/B VDD VSS sg13cmos5l_xor2_1
X_7132_ _7132_/Y _7132_/A _7191_/B VDD VSS sg13cmos5l_nand2_1
X_4344_ _4411_/B _4355_/A _4343_/Y VDD VSS sg13cmos5l_nor2b_1
X_7063_ _7063_/Y _7063_/A _7063_/B VDD VSS sg13cmos5l_nand2_1
X_6014_ _6017_/A _6018_/C _6046_/B VDD VSS sg13cmos5l_nand2_1
X_4275_ _4276_/C _4275_/A VDD VSS sg13cmos5l_inv_1
XFILLER_86_337 VDD VSS sg13cmos5l_fill_2
XFILLER_54_278 VDD VSS sg13cmos5l_decap_8
XFILLER_70_716 VDD VSS sg13cmos5l_fill_1
XFILLER_82_587 VDD VSS sg13cmos5l_decap_8
XFILLER_70_738 VDD VSS sg13cmos5l_fill_1
X_6916_ _6917_/B _6753_/Y _6916_/B VDD VSS sg13cmos5l_nand2b_1
X_6847_ _6945_/A _6847_/A _6847_/B VDD VSS sg13cmos5l_xor2_1
X_6778_ _6784_/A _7311_/A _7111_/A _7311_/B VDD VSS sg13cmos5l_nand3_1
X_5729_ _5731_/C _5927_/A _5729_/B VDD VSS sg13cmos5l_xnor2_1
XFILLER_117_20 VDD VSS sg13cmos5l_fill_1
Xrebuffer2060 _7133_/A2 _6932_/Y VDD VSS sg13cmos5l_buf_1
Xrebuffer1370 rebuffer1370/X rebuffer1371/X VDD VSS sg13cmos5l_buf_1
XFILLER_78_849 VDD VSS sg13cmos5l_decap_8
XFILLER_58_540 VDD VSS sg13cmos5l_fill_1
Xrebuffer1392 _7522_/A1 _7342_/A VDD VSS sg13cmos5l_buf_1
Xrebuffer1381 rebuffer1381/X rebuffer1382/X VDD VSS sg13cmos5l_buf_1
XFILLER_58_595 VDD VSS sg13cmos5l_decap_8
XFILLER_86_871 VDD VSS sg13cmos5l_decap_8
XFILLER_45_223 VDD VSS sg13cmos5l_decap_4
XFILLER_73_554 VDD VSS sg13cmos5l_decap_4
XFILLER_45_267 VDD VSS sg13cmos5l_decap_8
XFILLER_45_289 VDD VSS sg13cmos5l_decap_8
XFILLER_41_495 VDD VSS sg13cmos5l_fill_1
XFILLER_68_315 VDD VSS sg13cmos5l_decap_4
X_4060_ _4061_/B _4003_/A _4175_/A2 _4156_/A1 _4175_/B2 VDD VSS sg13cmos5l_a22oi_1
XFILLER_83_307 VDD VSS sg13cmos5l_decap_4
XFILLER_77_893 VDD VSS sg13cmos5l_decap_8
XFILLER_37_746 VDD VSS sg13cmos5l_fill_1
XFILLER_76_392 VDD VSS sg13cmos5l_decap_8
XFILLER_51_204 VDD VSS sg13cmos5l_decap_8
XFILLER_51_226 VDD VSS sg13cmos5l_decap_8
X_4962_ _4979_/B _4962_/A _4962_/B VDD VSS sg13cmos5l_xor2_1
X_7681_ _7681_/Q _7712_/CLK _7681_/D place750/X VDD VSS sg13cmos5l_dfrbpq_1
X_6701_ _6702_/A _7706_/Q _6703_/A VDD VSS sg13cmos5l_nor2_1
X_4893_ _4939_/B _5018_/A _4893_/B VDD VSS sg13cmos5l_xnor2_1
X_6632_ _6632_/Y _6632_/A _6631_/A VDD VSS sg13cmos5l_nor2b_1
XFILLER_22_19 VDD VSS sg13cmos5l_fill_2
X_6563_ _6860_/B _6571_/B _7690_/Q VDD VSS sg13cmos5l_nand2_1
X_6494_ _6495_/A _6504_/B _6504_/A VDD VSS sg13cmos5l_nor2_1
X_5514_ _5515_/B _5274_/A _5514_/A2 _5205_/A _5756_/B2 VDD VSS sg13cmos5l_a22oi_1
X_5445_ _5497_/A _5870_/A _5445_/B VDD VSS sg13cmos5l_xnor2_1
X_7115_ _7115_/Y _6797_/A _7187_/A _6321_/B VDD VSS sg13cmos5l_a21oi_1
X_5376_ _5377_/B _5376_/A _5427_/A VDD VSS sg13cmos5l_xnor2_1
XFILLER_87_613 VDD VSS sg13cmos5l_decap_8
X_4327_ _4328_/B _4447_/A _4447_/B _4327_/C VDD VSS sg13cmos5l_nor3_1
Xfanout158 _5442_/A _5192_/A VDD VSS sg13cmos5l_buf_1
X_7046_ _7046_/Y _7046_/A _7046_/B VDD VSS sg13cmos5l_nand2_1
X_4258_ _4258_/Y _4374_/A _6052_/A _4257_/Y VDD VSS sg13cmos5l_o21ai_1
XFILLER_87_668 VDD VSS sg13cmos5l_decap_8
X_4189_ _4189_/Y _4189_/A _4143_/B VDD VSS sg13cmos5l_nor2b_1
XFILLER_83_852 VDD VSS sg13cmos5l_decap_8
XFILLER_55_565 VDD VSS sg13cmos5l_fill_2
XFILLER_42_226 VDD VSS sg13cmos5l_fill_1
XFILLER_78_624 VDD VSS sg13cmos5l_fill_2
XFILLER_46_543 VDD VSS sg13cmos5l_decap_4
XFILLER_73_351 VDD VSS sg13cmos5l_fill_1
XFILLER_74_885 VDD VSS sg13cmos5l_decap_8
XFILLER_52_4 VDD VSS sg13cmos5l_fill_2
X_5230_ _5231_/B _5230_/A _5230_/B VDD VSS sg13cmos5l_nor2_1
X_5161_ _5173_/B _5222_/A _5161_/B VDD VSS sg13cmos5l_xnor2_1
X_5092_ _5092_/Y _5023_/A _5092_/B VDD VSS sg13cmos5l_nand2b_1
X_4112_ _4147_/A _4112_/A _4112_/B VDD VSS sg13cmos5l_nand2_1
X_4043_ _5898_/B _5810_/B _4044_/B VDD VSS sg13cmos5l_nor2_1
XFILLER_83_115 VDD VSS sg13cmos5l_fill_1
XFILLER_49_370 VDD VSS sg13cmos5l_decap_8
XFILLER_37_554 VDD VSS sg13cmos5l_decap_4
XFILLER_65_885 VDD VSS sg13cmos5l_decap_8
XFILLER_83_159 VDD VSS sg13cmos5l_decap_8
XFILLER_52_513 VDD VSS sg13cmos5l_fill_1
X_5994_ _6037_/B _6033_/B _5994_/B VDD VSS sg13cmos5l_xor2_1
XFILLER_80_822 VDD VSS sg13cmos5l_decap_8
X_4945_ _4948_/A _5012_/A1 _4946_/A _5012_/B1 VDD VSS sg13cmos5l_a21oi_1
XFILLER_52_579 VDD VSS sg13cmos5l_decap_4
XFILLER_80_899 VDD VSS sg13cmos5l_decap_8
XFILLER_60_590 VDD VSS sg13cmos5l_decap_8
X_7664_ _7664_/Q clkload1/A _7664_/D place747/X VDD VSS sg13cmos5l_dfrbpq_1
X_7595_ _7629_/C _7595_/A _7595_/B VDD VSS sg13cmos5l_xor2_1
X_6615_ _6623_/A _6615_/A _6615_/B VDD VSS sg13cmos5l_nor2_2
X_6546_ _6869_/A _6546_/A VDD VSS sg13cmos5l_inv_1
XFILLER_109_8 VDD VSS sg13cmos5l_decap_8
X_6477_ _6485_/B _6484_/A VDD VSS sg13cmos5l_inv_1
X_5428_ _5536_/A _5377_/B _5377_/A _5427_/Y VDD VSS sg13cmos5l_a21oi_1
X_5359_ _5359_/Y _5359_/A _5297_/A VDD VSS sg13cmos5l_nor2b_1
XFILLER_59_123 VDD VSS sg13cmos5l_decap_8
Xwire1004 _4701_/A wire1004/A VDD VSS sg13cmos5l_buf_2
XFILLER_87_454 VDD VSS sg13cmos5l_decap_8
X_7029_ _7162_/C _7029_/A _7054_/B VDD VSS sg13cmos5l_nand2_1
XFILLER_68_690 VDD VSS sg13cmos5l_fill_2
XFILLER_43_502 VDD VSS sg13cmos5l_decap_8
XFILLER_74_47 VDD VSS sg13cmos5l_fill_2
XFILLER_56_896 VDD VSS sg13cmos5l_decap_8
XFILLER_70_310 VDD VSS sg13cmos5l_decap_8
XFILLER_71_844 VDD VSS sg13cmos5l_decap_8
XFILLER_74_69 VDD VSS sg13cmos5l_fill_2
XFILLER_70_398 VDD VSS sg13cmos5l_fill_2
XFILLER_78_421 VDD VSS sg13cmos5l_fill_1
XFILLER_66_616 VDD VSS sg13cmos5l_fill_1
XFILLER_47_830 VDD VSS sg13cmos5l_decap_8
XFILLER_66_638 VDD VSS sg13cmos5l_decap_8
XFILLER_78_498 VDD VSS sg13cmos5l_decap_8
XFILLER_46_351 VDD VSS sg13cmos5l_fill_2
XFILLER_74_693 VDD VSS sg13cmos5l_fill_1
XFILLER_80_118 VDD VSS sg13cmos5l_fill_1
XFILLER_62_866 VDD VSS sg13cmos5l_decap_8
X_4730_ _4731_/A _4730_/A VDD VSS sg13cmos5l_inv_1
X_4661_ _4721_/B _4718_/A _4661_/B VDD VSS sg13cmos5l_xnor2_1
X_7380_ _7506_/A _7373_/A _7380_/B VDD VSS sg13cmos5l_nand2b_1
X_6400_ _6410_/A _6400_/A _6401_/A VDD VSS sg13cmos5l_nor2b_2
X_6331_ _6340_/A _6331_/A _6331_/B VDD VSS sg13cmos5l_nand2_2
X_4592_ _4593_/B _4446_/A _4592_/A2 _4389_/A _5017_/B2 VDD VSS sg13cmos5l_a22oi_1
Xrebuffer1903 _4613_/B _4612_/Y VDD VSS sg13cmos5l_buf_1
X_6262_ _6945_/B _7707_/Q VDD VSS sg13cmos5l_inv_2
Xrebuffer1936 rebuffer1936/X rebuffer1937/X VDD VSS sg13cmos5l_buf_1
Xrebuffer1925 rebuffer1925/X _5848_/A VDD VSS sg13cmos5l_buf_1
Xrebuffer1914 rebuffer1914/X rebuffer1915/X VDD VSS sg13cmos5l_buf_1
X_6193_ _6193_/Y _6205_/A _6193_/B VDD VSS sg13cmos5l_nor2_1
X_5213_ _5214_/B _5253_/A _5213_/B VDD VSS sg13cmos5l_xnor2_1
XFILLER_69_443 VDD VSS sg13cmos5l_decap_4
Xrebuffer1969 rebuffer1969/X rebuffer1970/X VDD VSS sg13cmos5l_buf_1
Xrebuffer1958 rebuffer1958/X rebuffer1959/X VDD VSS sg13cmos5l_buf_1
Xrebuffer1947 rebuffer1947/X rebuffer1948/X VDD VSS sg13cmos5l_buf_1
X_5144_ _5147_/A _5517_/A _5145_/A _5204_/B1 VDD VSS sg13cmos5l_a21oi_1
XFILLER_57_627 VDD VSS sg13cmos5l_decap_8
XFILLER_84_413 VDD VSS sg13cmos5l_fill_2
X_5075_ _5078_/A _3964_/A _5076_/A _5204_/B1 VDD VSS sg13cmos5l_a21oi_1
XFILLER_38_863 VDD VSS sg13cmos5l_decap_8
X_4026_ _4050_/A _4172_/B _4003_/A _4025_/Y VDD VSS sg13cmos5l_a21o_1
XFILLER_65_671 VDD VSS sg13cmos5l_decap_8
XFILLER_53_888 VDD VSS sg13cmos5l_decap_8
X_5977_ _5977_/Y _5977_/A _5977_/B VDD VSS sg13cmos5l_nand2_1
XFILLER_80_663 VDD VSS sg13cmos5l_decap_8
X_7716_ _7716_/Q clkload2/A _7716_/D place745/X VDD VSS sg13cmos5l_dfrbpq_1
X_4928_ _4928_/Y _4928_/A _4896_/B VDD VSS sg13cmos5l_nor2b_1
X_7647_ _7648_/B _7647_/A _7651_/A VDD VSS sg13cmos5l_nor2b_1
XFILLER_60_49 VDD VSS sg13cmos5l_decap_8
X_4859_ _4919_/S _4920_/B1 _5050_/A2 _4859_/B1 _4920_/B2 VDD VSS sg13cmos5l_a22oi_1
X_7578_ _7623_/C _7578_/A _7578_/B VDD VSS sg13cmos5l_xnor2_1
X_6529_ _6532_/B _6529_/A _7686_/Q _6552_/C VDD VSS sg13cmos5l_nand3_1
XFILLER_125_20 VDD VSS sg13cmos5l_fill_1
XFILLER_76_903 VDD VSS sg13cmos5l_decap_8
XFILLER_48_605 VDD VSS sg13cmos5l_decap_4
XFILLER_48_627 VDD VSS sg13cmos5l_fill_2
XFILLER_88_774 VDD VSS sg13cmos5l_fill_1
XFILLER_85_35 VDD VSS sg13cmos5l_fill_1
XFILLER_48_649 VDD VSS sg13cmos5l_fill_1
XFILLER_87_273 VDD VSS sg13cmos5l_fill_2
XFILLER_75_424 VDD VSS sg13cmos5l_fill_1
XFILLER_43_310 VDD VSS sg13cmos5l_decap_8
Xplace608 _4878_/B2 _4378_/B2 VDD VSS sg13cmos5l_buf_1
Xplace619 _4532_/A _4176_/A VDD VSS sg13cmos5l_buf_1
XFILLER_43_343 VDD VSS sg13cmos5l_fill_1
XFILLER_44_855 VDD VSS sg13cmos5l_decap_8
XFILLER_79_763 VDD VSS sg13cmos5l_decap_8
XFILLER_78_251 VDD VSS sg13cmos5l_fill_1
XFILLER_15_4 VDD VSS sg13cmos5l_decap_8
XFILLER_38_104 VDD VSS sg13cmos5l_fill_1
XFILLER_46_192 VDD VSS sg13cmos5l_decap_4
XFILLER_62_641 VDD VSS sg13cmos5l_decap_4
X_6880_ _6880_/Y _6880_/A _6880_/B VDD VSS sg13cmos5l_xnor2_1
XFILLER_81_449 VDD VSS sg13cmos5l_fill_1
X_5831_ _5928_/A _5833_/B _5833_/A VDD VSS sg13cmos5l_nor2_1
XFILLER_50_869 VDD VSS sg13cmos5l_decap_8
X_5762_ _5763_/B _6082_/A1 _4045_/Y _6082_/B1 _4074_/Y VDD VSS sg13cmos5l_a22oi_1
X_7501_ _7571_/A _7501_/A VDD VSS sg13cmos5l_inv_1
X_4713_ _4715_/A _4657_/B _4713_/B VDD VSS sg13cmos5l_nand2b_1
X_5693_ _5721_/A _5693_/A _5693_/B VDD VSS sg13cmos5l_xor2_1
XFILLER_30_19 VDD VSS sg13cmos5l_fill_2
X_7432_ _7434_/A _7432_/A _7582_/A _7498_/B _7574_/B VDD VSS sg13cmos5l_nand4_1
X_7363_ _7363_/Y _7363_/A _7377_/B VDD VSS sg13cmos5l_nor2_1
X_4575_ _4576_/B _5117_/B1 _4753_/A2 _5050_/B1 _4753_/B2 VDD VSS sg13cmos5l_a22oi_1
X_7294_ _7294_/X _7294_/A _7294_/B VDD VSS sg13cmos5l_and2_1
X_6314_ _6324_/A _6314_/A _6314_/B VDD VSS sg13cmos5l_nor2_2
X_6176_ _6177_/B _6176_/A _6175_/Y VDD VSS sg13cmos5l_nor2b_1
X_5127_ _5127_/Y _5127_/A _5087_/B VDD VSS sg13cmos5l_nor2b_1
XFILLER_85_744 VDD VSS sg13cmos5l_decap_8
XFILLER_84_221 VDD VSS sg13cmos5l_decap_4
XFILLER_73_917 VDD VSS sg13cmos5l_fill_1
X_5058_ _5058_/Y _5058_/A _5021_/B VDD VSS sg13cmos5l_nor2b_1
XFILLER_55_27 VDD VSS sg13cmos5l_fill_2
X_4009_ _4034_/A _4033_/A _4009_/B VDD VSS sg13cmos5l_xor2_1
XFILLER_41_803 VDD VSS sg13cmos5l_decap_8
XFILLER_80_460 VDD VSS sg13cmos5l_decap_8
XFILLER_71_26 VDD VSS sg13cmos5l_decap_8
XFILLER_40_379 VDD VSS sg13cmos5l_fill_1
XFILLER_105_2 VDD VSS sg13cmos5l_fill_1
XFILLER_48_435 VDD VSS sg13cmos5l_fill_1
XFILLER_76_777 VDD VSS sg13cmos5l_decap_8
XFILLER_63_416 VDD VSS sg13cmos5l_decap_8
XFILLER_75_298 VDD VSS sg13cmos5l_fill_2
XFILLER_44_663 VDD VSS sg13cmos5l_decap_4
XFILLER_43_195 VDD VSS sg13cmos5l_decap_8
XFILLER_61_70 VDD VSS sg13cmos5l_decap_4
XANTENNA_3 input811/X VDD VSS sg13cmos5l_antennanp
X_4360_ _4407_/A _4360_/A _4360_/B VDD VSS sg13cmos5l_nor2_1
X_4291_ _4292_/A _4295_/B _4291_/B VDD VSS sg13cmos5l_xor2_1
X_6030_ _6031_/B _6049_/B _6049_/A VDD VSS sg13cmos5l_xor2_1
Xbank_B_sram.gen_ihp_256x32.u_sram_256x32_1219 bank_B_sram.gen_ihp_256x32.u_sram_256x32/A_BM[10]
+ VDD VSS sg13cmos5l_tiehi
XFILLER_66_221 VDD VSS sg13cmos5l_fill_1
XFILLER_66_298 VDD VSS sg13cmos5l_fill_2
X_6932_ _6932_/Y _6928_/Y _7069_/B _6931_/X VDD VSS sg13cmos5l_a21oi_2
XFILLER_82_769 VDD VSS sg13cmos5l_decap_8
X_6863_ _6864_/A _6863_/A1 _6869_/B _6555_/B VDD VSS sg13cmos5l_a21oi_2
XFILLER_62_493 VDD VSS sg13cmos5l_fill_2
X_5814_ _5876_/A _5758_/A _5813_/Y _5711_/A VDD VSS sg13cmos5l_o21ai_1
X_6794_ _6794_/Y _6794_/A _7085_/B VDD VSS sg13cmos5l_nand2_1
X_5745_ _5791_/S _5792_/B1 _6136_/A _5745_/B1 _4496_/Y VDD VSS sg13cmos5l_a22oi_1
X_5676_ _5731_/A _5676_/A _5780_/A VDD VSS sg13cmos5l_nand2_1
X_7415_ _7579_/B _7415_/A _7415_/B VDD VSS sg13cmos5l_nand2_2
X_4627_ _4627_/Y _4627_/A _4596_/B VDD VSS sg13cmos5l_nor2b_1
X_7346_ _7518_/B _7353_/B _7360_/B VDD VSS sg13cmos5l_nand2_1
X_4558_ _4558_/Y _4537_/A _4558_/B VDD VSS sg13cmos5l_nand2b_1
X_7277_ _7277_/Y _7277_/A _7277_/B VDD VSS sg13cmos5l_nand2_1
X_4489_ _4489_/Y _4489_/A _4489_/B VDD VSS sg13cmos5l_nand2_1
X_6228_ _6228_/Y _6227_/A _6207_/Y _6227_/Y VDD VSS sg13cmos5l_o21ai_1
XFILLER_66_15 VDD VSS sg13cmos5l_fill_2
X_6159_ _6159_/Y _4495_/B _6136_/A _6136_/B VDD VSS sg13cmos5l_o21ai_1
XFILLER_85_541 VDD VSS sg13cmos5l_decap_8
XFILLER_72_235 VDD VSS sg13cmos5l_decap_4
XFILLER_73_769 VDD VSS sg13cmos5l_fill_1
XFILLER_40_110 VDD VSS sg13cmos5l_fill_1
XFILLER_81_791 VDD VSS sg13cmos5l_decap_8
XFILLER_41_677 VDD VSS sg13cmos5l_decap_8
XFILLER_40_154 VDD VSS sg13cmos5l_decap_8
XFILLER_68_508 VDD VSS sg13cmos5l_decap_8
XFILLER_49_755 VDD VSS sg13cmos5l_decap_8
XFILLER_63_224 VDD VSS sg13cmos5l_fill_1
X_5530_ _5532_/A _5470_/B _5530_/B VDD VSS sg13cmos5l_nand2b_1
X_5461_ _5461_/Y _5461_/A _5461_/B VDD VSS sg13cmos5l_nor2_1
X_4412_ _4475_/A _4349_/Y _4353_/B _4411_/X VDD VSS sg13cmos5l_a21o_1
Xbank_A_sram.gen_ihp_256x32.u_sram_256x32_1029 bank_A_sram.gen_ihp_256x32.u_sram_256x32_1029/L_LO
+ VDD VSS sg13cmos5l_tielo
X_5392_ _5402_/A _5757_/A _5392_/B VDD VSS sg13cmos5l_xnor2_1
X_7131_ _7131_/Y _7130_/Y _7301_/A2 _7059_/Y VDD VSS sg13cmos5l_a21oi_1
X_4343_ _4343_/Y _4343_/A _4343_/B _4343_/C VDD VSS sg13cmos5l_nand3_1
X_7062_ _7063_/B _6940_/Y _7072_/B VDD VSS sg13cmos5l_nand2b_1
X_4274_ _4277_/A _3972_/A _4275_/A _3976_/B VDD VSS sg13cmos5l_a21oi_1
X_6013_ _6046_/B _6012_/B _6013_/B VDD VSS sg13cmos5l_nand2b_1
XFILLER_86_327 VDD VSS sg13cmos5l_fill_1
XFILLER_39_298 VDD VSS sg13cmos5l_fill_2
XFILLER_55_747 VDD VSS sg13cmos5l_decap_4
X_6915_ _6915_/Y _6916_/B _6915_/B VDD VSS sg13cmos5l_nor2_1
X_6846_ _6846_/Y _6840_/Y _7061_/B _6845_/Y VDD VSS sg13cmos5l_a21oi_1
X_6777_ _7311_/B _6776_/X _7294_/B VDD VSS sg13cmos5l_nand2b_1
XFILLER_50_496 VDD VSS sg13cmos5l_fill_1
X_5728_ _5729_/B _5782_/B _5782_/A VDD VSS sg13cmos5l_xnor2_1
X_3989_ _4013_/A _4015_/B _4014_/B VDD VSS sg13cmos5l_nor2_1
X_5659_ _5665_/B _5659_/A VDD VSS sg13cmos5l_inv_1
X_7329_ _7336_/A _7289_/A _7326_/Y _7328_/Y VDD VSS sg13cmos5l_o21ai_1
Xrebuffer2050 _6842_/B _6471_/A VDD VSS sg13cmos5l_buf_1
XFILLER_78_828 VDD VSS sg13cmos5l_decap_8
XFILLER_77_305 VDD VSS sg13cmos5l_decap_8
Xrebuffer1371 rebuffer1371/X rebuffer1372/X VDD VSS sg13cmos5l_buf_1
Xrebuffer1360 rebuffer1360/X rebuffer1361/X VDD VSS sg13cmos5l_buf_1
XFILLER_77_47 VDD VSS sg13cmos5l_decap_8
XFILLER_77_327 VDD VSS sg13cmos5l_decap_8
Xrebuffer1393 _6740_/A1 _6661_/A VDD VSS sg13cmos5l_buf_1
Xrebuffer1382 rebuffer1382/X rebuffer1383/X VDD VSS sg13cmos5l_buf_1
XFILLER_86_850 VDD VSS sg13cmos5l_decap_8
XFILLER_46_703 VDD VSS sg13cmos5l_fill_1
XFILLER_46_758 VDD VSS sg13cmos5l_fill_2
XFILLER_61_728 VDD VSS sg13cmos5l_decap_4
XFILLER_60_227 VDD VSS sg13cmos5l_fill_1
XFILLER_41_441 VDD VSS sg13cmos5l_decap_8
XFILLER_41_452 VDD VSS sg13cmos5l_fill_2
XFILLER_3_11 VDD VSS sg13cmos5l_decap_8
XFILLER_77_872 VDD VSS sg13cmos5l_decap_8
XFILLER_37_769 VDD VSS sg13cmos5l_fill_1
X_4961_ _4962_/B _5030_/B _5030_/A VDD VSS sg13cmos5l_xor2_1
XFILLER_51_249 VDD VSS sg13cmos5l_fill_1
X_7680_ _7680_/Q clkload0/A _7680_/D place748/X VDD VSS sg13cmos5l_dfrbpq_1
X_6700_ _6703_/A _7274_/A _6700_/B VDD VSS sg13cmos5l_nor2_1
X_4892_ _4893_/B _4766_/A _3951_/A _4701_/A _5017_/B2 VDD VSS sg13cmos5l_a22oi_1
XFILLER_60_761 VDD VSS sg13cmos5l_decap_8
XFILLER_60_783 VDD VSS sg13cmos5l_decap_8
X_6631_ _6647_/A _6631_/A _6631_/B _6631_/C VDD VSS sg13cmos5l_nor3_2
XFILLER_73_0 VDD VSS sg13cmos5l_fill_2
X_6562_ _6571_/B _6567_/B _6567_/A _6561_/Y VDD VSS sg13cmos5l_o21ai_1
X_6493_ _6504_/A _6491_/Y _6508_/A _6502_/C VDD VSS sg13cmos5l_o21ai_1
X_5513_ _5526_/A _5466_/B _5466_/A _5512_/Y VDD VSS sg13cmos5l_a21oi_1
X_5444_ _5445_/B _5949_/B1 _5869_/A2 _5909_/B1 _5869_/B2 VDD VSS sg13cmos5l_a22oi_1
X_7114_ _7114_/Y _7114_/A _7168_/B VDD VSS sg13cmos5l_nand2_1
X_5375_ _5427_/A _5327_/B _5327_/A _5374_/X VDD VSS sg13cmos5l_a21oi_1
XFILLER_59_327 VDD VSS sg13cmos5l_decap_8
X_4326_ _4327_/C _4326_/A VDD VSS sg13cmos5l_inv_1
XFILLER_59_349 VDD VSS sg13cmos5l_decap_8
X_7045_ _7046_/A _7045_/A _7045_/B VDD VSS sg13cmos5l_nand2_1
X_4257_ _4257_/Y _6053_/B _4257_/B VDD VSS sg13cmos5l_nand2_1
XFILLER_87_647 VDD VSS sg13cmos5l_decap_8
XFILLER_68_894 VDD VSS sg13cmos5l_decap_8
X_4188_ _4188_/X _4188_/A _4243_/C VDD VSS sg13cmos5l_xor2_1
XFILLER_83_831 VDD VSS sg13cmos5l_decap_8
XFILLER_70_514 VDD VSS sg13cmos5l_decap_8
X_6829_ _6829_/Y _7087_/A _6829_/B VDD VSS sg13cmos5l_nor2_1
XFILLER_50_282 VDD VSS sg13cmos5l_fill_2
XFILLER_78_669 VDD VSS sg13cmos5l_decap_8
XFILLER_46_500 VDD VSS sg13cmos5l_fill_1
XFILLER_65_308 VDD VSS sg13cmos5l_fill_2
XFILLER_37_61 VDD VSS sg13cmos5l_fill_1
XFILLER_46_577 VDD VSS sg13cmos5l_decap_8
XFILLER_74_864 VDD VSS sg13cmos5l_decap_8
XFILLER_46_599 VDD VSS sg13cmos5l_fill_2
X_5160_ _5161_/B _5160_/A _5160_/B VDD VSS sg13cmos5l_xor2_1
X_5091_ _5091_/Y _5091_/A VDD VSS sg13cmos5l_inv_1
X_4111_ _4112_/B _4093_/B _4111_/B VDD VSS sg13cmos5l_nand2b_1
X_4042_ _4068_/A _4036_/B _4042_/B VDD VSS sg13cmos5l_nand2b_1
XFILLER_49_393 VDD VSS sg13cmos5l_decap_4
XFILLER_84_639 VDD VSS sg13cmos5l_decap_8
XFILLER_83_138 VDD VSS sg13cmos5l_decap_4
XFILLER_37_544 VDD VSS sg13cmos5l_decap_4
XFILLER_65_864 VDD VSS sg13cmos5l_decap_8
XFILLER_80_801 VDD VSS sg13cmos5l_decap_8
XFILLER_52_503 VDD VSS sg13cmos5l_fill_2
XFILLER_52_536 VDD VSS sg13cmos5l_fill_2
X_5993_ _5994_/B _5993_/A _5993_/B VDD VSS sg13cmos5l_xnor2_1
XFILLER_80_878 VDD VSS sg13cmos5l_decap_8
X_7663_ _7663_/Q _7679_/CLK _7663_/D place748/X VDD VSS sg13cmos5l_dfrbpq_1
X_7594_ _7595_/B _7594_/A _7594_/B VDD VSS sg13cmos5l_nand2_1
X_6614_ _6615_/B _6614_/A VDD VSS sg13cmos5l_inv_1
X_6545_ _6546_/A _6554_/B _6554_/A VDD VSS sg13cmos5l_nor2_1
X_6476_ _6484_/A _6476_/A _6476_/B VDD VSS sg13cmos5l_nand2_2
X_5427_ _5427_/Y _5427_/A _5376_/A VDD VSS sg13cmos5l_nor2b_1
XFILLER_59_102 VDD VSS sg13cmos5l_decap_4
X_5358_ _5362_/A _5358_/A VDD VSS sg13cmos5l_inv_1
Xwire1005 _4646_/A wire1005/A VDD VSS sg13cmos5l_buf_2
X_4309_ _4318_/A _4374_/A _4309_/B VDD VSS sg13cmos5l_xnor2_1
XFILLER_87_433 VDD VSS sg13cmos5l_decap_8
XFILLER_114_11 VDD VSS sg13cmos5l_decap_8
XFILLER_59_168 VDD VSS sg13cmos5l_fill_1
Xwire1016 _4583_/B1 wire1016/A VDD VSS sg13cmos5l_buf_2
X_7028_ _7162_/A _7028_/A _7069_/B VDD VSS sg13cmos5l_nand2_1
X_5289_ _5290_/B _5351_/B _5351_/A VDD VSS sg13cmos5l_xor2_1
XFILLER_87_488 VDD VSS sg13cmos5l_decap_8
XFILLER_55_330 VDD VSS sg13cmos5l_decap_8
XFILLER_56_875 VDD VSS sg13cmos5l_decap_8
XFILLER_74_26 VDD VSS sg13cmos5l_fill_2
XFILLER_71_823 VDD VSS sg13cmos5l_decap_8
XFILLER_55_396 VDD VSS sg13cmos5l_decap_4
XFILLER_70_333 VDD VSS sg13cmos5l_decap_4
XFILLER_51_591 VDD VSS sg13cmos5l_fill_2
Xbank_A_sram.gen_ihp_256x32.u_sram_256x32_1190 bank_A_sram.gen_ihp_256x32.u_sram_256x32/A_BM[15]
+ VDD VSS sg13cmos5l_tiehi
XFILLER_78_455 VDD VSS sg13cmos5l_fill_2
XFILLER_48_82 VDD VSS sg13cmos5l_fill_2
XFILLER_46_330 VDD VSS sg13cmos5l_decap_8
XFILLER_81_609 VDD VSS sg13cmos5l_decap_8
XFILLER_47_886 VDD VSS sg13cmos5l_decap_8
XFILLER_74_672 VDD VSS sg13cmos5l_decap_8
XFILLER_62_845 VDD VSS sg13cmos5l_decap_8
X_4660_ _4661_/B _4660_/A _4660_/B VDD VSS sg13cmos5l_xor2_1
X_6330_ _6331_/A _6791_/B _6330_/B VDD VSS sg13cmos5l_nand2_2
X_4591_ _4638_/A _4767_/B _4524_/A _4590_/Y VDD VSS sg13cmos5l_a21o_1
XFILLER_50_2 VDD VSS sg13cmos5l_fill_1
X_6261_ _6279_/A _7709_/Q _6261_/B VDD VSS sg13cmos5l_nor2_2
Xrebuffer1937 rebuffer1937/X rebuffer1938/X VDD VSS sg13cmos5l_buf_1
Xrebuffer1926 rebuffer1926/X rebuffer1927/X VDD VSS sg13cmos5l_buf_1
Xrebuffer1915 rebuffer1915/X rebuffer1916/X VDD VSS sg13cmos5l_buf_1
Xrebuffer1904 _4191_/B _4241_/A VDD VSS sg13cmos5l_buf_1
X_6192_ _6192_/Y _6192_/A VDD VSS sg13cmos5l_inv_1
X_5212_ _5213_/B _5212_/A _5212_/B VDD VSS sg13cmos5l_xor2_1
XFILLER_88_219 VDD VSS sg13cmos5l_decap_8
Xrebuffer1959 rebuffer1959/X rebuffer1960/X VDD VSS sg13cmos5l_buf_1
Xrebuffer1948 rebuffer1948/X rebuffer1949/X VDD VSS sg13cmos5l_buf_1
XFILLER_28_19 VDD VSS sg13cmos5l_fill_2
XFILLER_56_105 VDD VSS sg13cmos5l_fill_2
XFILLER_56_127 VDD VSS sg13cmos5l_fill_2
XFILLER_38_842 VDD VSS sg13cmos5l_decap_8
XFILLER_49_190 VDD VSS sg13cmos5l_fill_1
XFILLER_53_801 VDD VSS sg13cmos5l_fill_2
XFILLER_72_609 VDD VSS sg13cmos5l_decap_8
X_4025_ _4025_/Y _4025_/A _4025_/B VDD VSS sg13cmos5l_nor2_1
XFILLER_52_300 VDD VSS sg13cmos5l_decap_8
XFILLER_64_160 VDD VSS sg13cmos5l_decap_8
XFILLER_52_344 VDD VSS sg13cmos5l_fill_2
XFILLER_53_867 VDD VSS sg13cmos5l_decap_8
XFILLER_80_642 VDD VSS sg13cmos5l_decap_8
X_5976_ _6037_/A _5947_/B _5947_/A _5975_/Y VDD VSS sg13cmos5l_a21oi_1
XFILLER_40_528 VDD VSS sg13cmos5l_fill_2
X_7715_ _7715_/Q _7720_/CLK _7715_/D place745/X VDD VSS sg13cmos5l_dfrbpq_1
X_4927_ _5025_/A _4927_/A _4927_/B VDD VSS sg13cmos5l_xor2_1
XFILLER_60_28 VDD VSS sg13cmos5l_fill_1
X_7646_ _7647_/A _7646_/A1 _7641_/B _7123_/B VDD VSS sg13cmos5l_a21oi_1
X_4858_ _4866_/A _4802_/B _4854_/A _4858_/S VDD VSS sg13cmos5l_mux2_1
X_7577_ _7578_/B _7503_/B _7503_/A _7414_/B VDD VSS sg13cmos5l_a21oi_1
X_4789_ _7678_/D _4847_/B _4789_/B VDD VSS sg13cmos5l_xor2_1
X_6528_ _6530_/A _6529_/A _6502_/C _7686_/Q VDD VSS sg13cmos5l_a21oi_1
XFILLER_69_37 VDD VSS sg13cmos5l_decap_8
XFILLER_88_742 VDD VSS sg13cmos5l_decap_4
XFILLER_88_731 VDD VSS sg13cmos5l_decap_8
XFILLER_48_617 VDD VSS sg13cmos5l_fill_1
XFILLER_87_263 VDD VSS sg13cmos5l_decap_8
XFILLER_85_58 VDD VSS sg13cmos5l_fill_2
XFILLER_63_609 VDD VSS sg13cmos5l_decap_8
XFILLER_44_834 VDD VSS sg13cmos5l_decap_8
Xplace609 _4378_/B2 _4160_/Y VDD VSS sg13cmos5l_buf_1
XFILLER_55_171 VDD VSS sg13cmos5l_decap_8
XFILLER_71_620 VDD VSS sg13cmos5l_decap_8
XFILLER_71_631 VDD VSS sg13cmos5l_fill_2
XFILLER_71_675 VDD VSS sg13cmos5l_decap_8
XFILLER_43_388 VDD VSS sg13cmos5l_fill_1
XFILLER_79_720 VDD VSS sg13cmos5l_decap_8
XFILLER_66_403 VDD VSS sg13cmos5l_decap_8
XFILLER_38_127 VDD VSS sg13cmos5l_decap_8
XFILLER_78_296 VDD VSS sg13cmos5l_fill_1
XFILLER_81_428 VDD VSS sg13cmos5l_fill_1
XFILLER_61_141 VDD VSS sg13cmos5l_fill_1
X_5830_ _5833_/A _5830_/A VDD VSS sg13cmos5l_inv_1
XFILLER_50_848 VDD VSS sg13cmos5l_decap_8
X_5761_ _5767_/A _5982_/A _5761_/B VDD VSS sg13cmos5l_xnor2_1
X_7500_ _7572_/A _7500_/A VDD VSS sg13cmos5l_inv_1
X_4712_ _4716_/A _4778_/B _4712_/B VDD VSS sg13cmos5l_xnor2_1
X_7431_ _7574_/B _7431_/A _7431_/B VDD VSS sg13cmos5l_nand2_1
X_5692_ _5693_/B _5692_/A _5739_/A VDD VSS sg13cmos5l_xnor2_1
X_4643_ _4653_/A _4643_/A _4643_/B VDD VSS sg13cmos5l_xnor2_1
X_7362_ _7363_/A _7369_/A _7362_/B VDD VSS sg13cmos5l_nor2_1
X_7293_ _7304_/B _7556_/A _7554_/B VDD VSS sg13cmos5l_and2_1
X_6313_ _6324_/B _6602_/A _6611_/B _6611_/C VDD VSS sg13cmos5l_nand3_1
X_6244_ _6244_/Y _6533_/B _6255_/A _6255_/C _6698_/A VDD VSS sg13cmos5l_nand4_1
XFILLER_69_230 VDD VSS sg13cmos5l_decap_8
XFILLER_69_241 VDD VSS sg13cmos5l_fill_2
X_6175_ _6175_/Y _6175_/A _6175_/B _6175_/C VDD VSS sg13cmos5l_nand3_1
XFILLER_69_263 VDD VSS sg13cmos5l_fill_1
X_5126_ _5217_/B _5126_/A _5126_/B VDD VSS sg13cmos5l_xor2_1
XFILLER_85_723 VDD VSS sg13cmos5l_decap_8
X_5057_ _5157_/A _5057_/A _5057_/B VDD VSS sg13cmos5l_xor2_1
XFILLER_38_661 VDD VSS sg13cmos5l_decap_4
X_4008_ _4009_/B _5645_/A _4008_/B VDD VSS sg13cmos5l_xnor2_1
XFILLER_53_620 VDD VSS sg13cmos5l_fill_1
XFILLER_40_325 VDD VSS sg13cmos5l_decap_8
XFILLER_41_859 VDD VSS sg13cmos5l_decap_8
XFILLER_52_163 VDD VSS sg13cmos5l_decap_4
XFILLER_52_185 VDD VSS sg13cmos5l_decap_8
X_5959_ _5998_/A _5999_/B _5999_/A VDD VSS sg13cmos5l_xor2_1
X_7629_ _7630_/A _7629_/A _7629_/B _7629_/C _7629_/D VDD VSS sg13cmos5l_nand4_1
XFILLER_112_4 VDD VSS sg13cmos5l_decap_8
XFILLER_48_403 VDD VSS sg13cmos5l_fill_1
XFILLER_75_244 VDD VSS sg13cmos5l_fill_1
XFILLER_75_222 VDD VSS sg13cmos5l_fill_2
XFILLER_63_428 VDD VSS sg13cmos5l_fill_1
XFILLER_75_266 VDD VSS sg13cmos5l_fill_2
XFILLER_71_472 VDD VSS sg13cmos5l_decap_8
Xclkbuf_4_12_0_clk_i_regs _7702_/CLK clkbuf_0_clk_i_regs/X VDD VSS sg13cmos5l_buf_8
XFILLER_6_11 VDD VSS sg13cmos5l_decap_8
XANTENNA_4 input822/X VDD VSS sg13cmos5l_antennanp
X_4290_ _4291_/B _4296_/B _4290_/B VDD VSS sg13cmos5l_xor2_1
XFILLER_79_561 VDD VSS sg13cmos5l_decap_8
XFILLER_66_211 VDD VSS sg13cmos5l_fill_2
Xbank_B_sram.gen_ihp_256x32.u_sram_256x32_1209 bank_B_sram.gen_ihp_256x32.u_sram_256x32/A_BM[0]
+ VDD VSS sg13cmos5l_tiehi
XFILLER_67_767 VDD VSS sg13cmos5l_decap_4
XFILLER_66_277 VDD VSS sg13cmos5l_decap_4
XFILLER_81_203 VDD VSS sg13cmos5l_fill_1
XFILLER_54_439 VDD VSS sg13cmos5l_decap_4
X_6931_ _6931_/X _6931_/A _7072_/B VDD VSS sg13cmos5l_and2_1
XFILLER_82_748 VDD VSS sg13cmos5l_decap_8
XFILLER_81_247 VDD VSS sg13cmos5l_decap_8
XFILLER_62_450 VDD VSS sg13cmos5l_fill_1
X_6862_ _6862_/X _6862_/A _6862_/B VDD VSS sg13cmos5l_xor2_1
XFILLER_81_258 VDD VSS sg13cmos5l_fill_1
XFILLER_50_623 VDD VSS sg13cmos5l_decap_4
X_5813_ _5813_/Y _5813_/A VDD VSS sg13cmos5l_inv_1
XFILLER_50_645 VDD VSS sg13cmos5l_decap_8
XFILLER_50_656 VDD VSS sg13cmos5l_fill_1
X_6793_ _6794_/A _6968_/A _6955_/B _6792_/Y VDD VSS sg13cmos5l_a21oi_1
X_5744_ _5752_/A _5689_/B _5547_/A _5744_/S VDD VSS sg13cmos5l_mux2_1
X_5675_ _7692_/D _5675_/A _5734_/A VDD VSS sg13cmos5l_nor2b_1
X_7414_ _7415_/B _7414_/A _7414_/B _7414_/C VDD VSS sg13cmos5l_nor3_1
X_4626_ _4713_/B _4626_/A _4626_/B VDD VSS sg13cmos5l_xor2_1
X_7345_ _7353_/B _7369_/A _7137_/Y _7344_/Y VDD VSS sg13cmos5l_o21ai_1
X_4557_ _4557_/Y _4557_/A VDD VSS sg13cmos5l_inv_1
X_7276_ _7276_/X _7192_/Y _7178_/X _7276_/S VDD VSS sg13cmos5l_mux2_1
X_4488_ _5045_/A _4854_/A VDD VSS sg13cmos5l_inv_1
X_6227_ _6227_/Y _6227_/A _6227_/B VDD VSS sg13cmos5l_nand2_1
XFILLER_77_509 VDD VSS sg13cmos5l_fill_2
XFILLER_57_200 VDD VSS sg13cmos5l_decap_8
XFILLER_57_211 VDD VSS sg13cmos5l_fill_2
X_6158_ _6178_/A _6149_/Y _6168_/A _6150_/A VDD VSS sg13cmos5l_a21oi_1
X_5109_ _5111_/A _5109_/A _5109_/B VDD VSS sg13cmos5l_nand2_1
XFILLER_57_255 VDD VSS sg13cmos5l_decap_4
XFILLER_58_789 VDD VSS sg13cmos5l_fill_1
X_6089_ _6090_/B _6089_/A _6123_/B VDD VSS sg13cmos5l_nand2_1
XFILLER_85_597 VDD VSS sg13cmos5l_decap_8
XFILLER_60_409 VDD VSS sg13cmos5l_decap_8
XFILLER_15_20 VDD VSS sg13cmos5l_fill_1
XFILLER_41_601 VDD VSS sg13cmos5l_fill_1
XFILLER_81_770 VDD VSS sg13cmos5l_decap_8
XFILLER_49_701 VDD VSS sg13cmos5l_decap_8
XFILLER_49_734 VDD VSS sg13cmos5l_decap_8
XFILLER_49_789 VDD VSS sg13cmos5l_fill_2
XFILLER_64_715 VDD VSS sg13cmos5l_decap_8
XFILLER_64_726 VDD VSS sg13cmos5l_fill_1
XFILLER_56_71 VDD VSS sg13cmos5l_fill_1
XFILLER_56_82 VDD VSS sg13cmos5l_fill_1
XFILLER_51_409 VDD VSS sg13cmos5l_fill_2
XFILLER_72_92 VDD VSS sg13cmos5l_decap_8
X_5460_ _5461_/B _5460_/A _5460_/B _5460_/C VDD VSS sg13cmos5l_nor3_1
XFILLER_75_4 VDD VSS sg13cmos5l_fill_2
X_4411_ _4411_/X _4411_/A _4411_/B VDD VSS sg13cmos5l_and2_1
X_5391_ _5392_/B _5145_/A _5514_/A2 _5076_/A _5756_/B2 VDD VSS sg13cmos5l_a22oi_1
X_7130_ _7130_/Y _7126_/Y _7109_/A _7129_/Y VDD VSS sg13cmos5l_a21oi_1
X_4342_ _4355_/A _4343_/A _4343_/B _4343_/C VDD VSS sg13cmos5l_a21oi_1
X_7061_ _7063_/A _7061_/A _7061_/B VDD VSS sg13cmos5l_nand2_1
XFILLER_87_829 VDD VSS sg13cmos5l_decap_8
X_6012_ _6018_/C _6013_/B _6012_/B VDD VSS sg13cmos5l_nand2b_1
.ends
